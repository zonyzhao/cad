procedure( pcGenCell( pcCellView "d")
let( ( 	pcMember pcStretchGroup stretchOffsetX stretchOffsetY
