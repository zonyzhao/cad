simulator lang=spice

.model pmos pmos level=2
+ vto = -0.9
+ tox = 430e-10
+ nsub = 6.6e+15
+ xj = 0.05U
*+ ld = 0.20U
+ ld = 0.075U
+ u0 = 240
+ ucrit = 0.86e5
+ uexp = 0.29
+ vmax = 3.0e4
+ neff = 2.65
+ delta = 1.0
+ rsh = 110
+ cgso = 2.05e-10
+ cgdo = 2.05e-10
+ cj = 275U
+ cjsw = 400P
+ mj = 0.535
+ mjsw = 0.34
+ pb = 0.8
