simulator lang=spice
* VTI-derived Level=2 nominal model
.model nmos nmos level=2
+ vto = 0.775
+ tox = 400e-10
+ nsub = 8e+15
+ xj = 0.15U
+ ld = 0.20U
+ u0 = 650
+ ucrit = 0.62e+5
+ uexp = 0.125
+ vmax = 5.1e+4
+ neff = 4.0
+ delta = 1.4
+ rsh = 36
+ cgso = 1.95e-10
+ cgdo = 1.95e-10
+ cj = 195U
+ cjsw = 500P
+ mj = 0.76
+ mjsw = 0.30
+ pb = 0.8
