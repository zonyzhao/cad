;;;;;;;;;;;;;;;;;;;;;;;;;;;;;;;;;;;;;;;;;;;;;;;;;;;;;;;;;;;;;;;;;;;;;;;;;;;;;;;;
;  rectTran.ils: Rectangle transform class
;  FIXME: This seems like it should inherit from bbox. Needs a big refactor!!
;;;;;;;;;;;;;;;;;;;;;;;;;;;;;;;;;;;;;;;;;;;;;;;;;;;;;;;;;;;;;;;;;;;;;;;;;;;;;;;;
defclass( rectTran (cadObj)
	  (
		( ur @reader getUrPnt)
		( ll @reader getllPnt)
		( width @reader getWidth)
		( height @reader getHeight)
		( transformation @reader getTrans)
	  )
) ; defClass

;;;;;;;;;;;;;;;;;;;;;;;;;;;;;;;;;;;;;;;;;;;;;;;;;;;;;;;;
; Constructor method
;;;;;;;;;;;;;;;;;;;;;;;;;;;;;;;;;;;;;;;;;;;;;;;;;;;;;;;;
defmethod( initializeInstance @after ((obj rectTran))
	   obj->ur = makeInstance( 'point2 )
	   obj->ll = makeInstance( 'point2 )
	   obj->width = nil
	   obj->height = nil
	   obj->transformation = makeInstance( 'transformation2 )
);defmethod

;;;;;;;;;;;;;;;;;;;;;;;;;;;;;;;;;;;;;;;;;;;;;;;;;;;;;;;;;;;;;;;;;;;;;;;;;
; Calculates the centroid of the rectTran
;;;;;;;;;;;;;;;;;;;;;;;;;;;;;;;;;;;;;;;;;;;;;;;;;;;;;;;;;;;;;;;;;;;;;;;;;
defmethod( calculateCentroid (( rt rectTran ))
  let( (urx ury llx lly xval yval)
    urx = xCoord(getUpperRight(rt))
    ury = yCoord(getUpperRight(rt))
    llx = xCoord(getLowerLeft(rt))
    lly = yCoord(getLowerLeft(rt))
    xval = (urx+llx)/2
    yval = (ury+lly)/2
    setCentroid(rt->transformation list(xval yval))
  );let
);defmethod

;;;;;;;;;;;;;;;;;;;;;;;;;;;;;;;;;;;;;;;;;;;;;;;;;;;;;;;;;;
; Checks if the rectTran is centered at that origin
;;;;;;;;;;;;;;;;;;;;;;;;;;;;;;;;;;;;;;;;;;;;;;;;;;;;;;;;;;
defmethod( isCentered (( rt rectTran ))
  if( abs(xCoord(getCentroid(rt->transformation))) < 1e-6 && abs(yCoord(getCentroid(rt->transformation))) < 1e-6 then
    t
  else
    nil
  );if
);defmethod

;;;;;;;;;;;;;;;;;;;;;;;;;;;;;;;;;;;;;;;;;;;;;;;;;;;;;;;;;;
; Centers the rectTran about the origin
;;;;;;;;;;;;;;;;;;;;;;;;;;;;;;;;;;;;;;;;;;;;;;;;;;;;;;;;;;
defmethod( center (( rt rectTran ))
  let( (cx cy)
    if( !isCentered(rt) then
      translate(rt -1*xCoord(getCentroid(rt->transformation)))
      setLowerLeft(rt -1*yCoord(getCentroid(rt->transformation)))
      setCentroid(rt->transformation list(0.0 0.0))
    );if
  );let
);defmethod

;;;;;;;;;;;;;;;;;;;;;;;;;;;;;;;;;;;;;;;;;;;;;;;;;;;;;;;;;;;;;;;;;;;;;;;;;
; Set Upper Right
;;;;;;;;;;;;;;;;;;;;;;;;;;;;;;;;;;;;;;;;;;;;;;;;;;;;;;;;;;;;;;;;;;;;;;;;;
defmethod( setUpperRight (( rt rectTran ) arg )
  setCoord(rt->ur arg)
);defmethod

;;;;;;;;;;;;;;;;;;;;;;;;;;;;;;;;;;;;;;;;;;;;;;;;;;;;;;;;;;;;;;;;;;;;;;;;;
; Get Upper Right
;;;;;;;;;;;;;;;;;;;;;;;;;;;;;;;;;;;;;;;;;;;;;;;;;;;;;;;;;;;;;;;;;;;;;;;;;
defmethod( getUpperRight (( rt rectTran ))
  getCoord(rt->ur)
);defmethod

;;;;;;;;;;;;;;;;;;;;;;;;;;;;;;;;;;;;;;;;;;;;;;;;;;;;;;;;;;;;;;;;;;;;;;;;;
; Set Upper Right
;;;;;;;;;;;;;;;;;;;;;;;;;;;;;;;;;;;;;;;;;;;;;;;;;;;;;;;;;;;;;;;;;;;;;;;;;
defmethod( setLowerLeft (( rt rectTran ) arg )
  setCoord(rt->ll arg)
);defmethod

;;;;;;;;;;;;;;;;;;;;;;;;;;;;;;;;;;;;;;;;;;;;;;;;;;;;;;;;;;;;;;;;;;;;;;;;;
; Get Upper Right
;;;;;;;;;;;;;;;;;;;;;;;;;;;;;;;;;;;;;;;;;;;;;;;;;;;;;;;;;;;;;;;;;;;;;;;;;
defmethod( getLowerLeft (( rt rectTran ))
  getCoord(rt->ll)
);defmethod

;;;;;;;;;;;;;;;;;;;;;;;;;;;;;;;;;;;;;;;;;;;;;;;;;;;;;;;;;;;;;;;;;;;;;;;;;
; sets the centroid of the rectTran
;;;;;;;;;;;;;;;;;;;;;;;;;;;;;;;;;;;;;;;;;;;;;;;;;;;;;;;;;;;;;;;;;;;;;;;;;
defmethod( setCentroid (( rt rectTran ) arg)
  setCentroid(rt->transformation arg)
);defmethod

;;;;;;;;;;;;;;;;;;;;;;;;;;;;;;;;;;;;;;;;;;;;;;;;;;;;;;;;;;;;;;;;;;;;;;;;;
; gets the centroid of the rectTran
;;;;;;;;;;;;;;;;;;;;;;;;;;;;;;;;;;;;;;;;;;;;;;;;;;;;;;;;;;;;;;;;;;;;;;;;;
defmethod( getCentroid (( rt rectTran ))
  getCentroid(rt->transformation)
);defmethod

;;;;;;;;;;;;;;;;;;;;;;;;;;;;;;;;;;;;;;;;;;;;;;;;;;;;;;;;;;;;;;;;;;;;;;;;;
; Zeros out the rectTran
;;;;;;;;;;;;;;;;;;;;;;;;;;;;;;;;;;;;;;;;;;;;;;;;;;;;;;;;;;;;;;;;;;;;;;;;;
defmethod( zero (( rt rectTran ))
  setCentroid(rt list(0.0 0.0))
  setUpperRight(rt list(0.0 0.0))
  setLowerLeft(rt list(0.0 0.0))
);defmethod

;;;;;;;;;;;;;;;;;;;;;;;;;;;;;;;;;;;;;;;;;;;;;;;;;;;;;;;;;;;;;;;;;;;;;;;;;
; Clone the current rectTran to the input recTran argument
;;;;;;;;;;;;;;;;;;;;;;;;;;;;;;;;;;;;;;;;;;;;;;;;;;;;;;;;;;;;;;;;;;;;;;;;;
defmethod( clone (( rt rectTran ) arg)
  if( classp(arg 'rectTran) then
    println("INFO(rectran): Cloning a rectTran")
    setUpperRight(rt getUpperRight(arg))
    setLowerLeft(rt getLowerLeft(arg))
    setCentroid(rt getCentroid(arg))
  else
    println("ERROR(rectTran): recTran object argument required")
  );
);defMethod

;;;;;;;;;;;;;;;;;;;;;;;;;;;;;;;;;;;;;;;;;;;;;;;;;;;;;;;;;;;;;;;;;;;;;;;;;
; Area of recTran - rectTran must be centered about origin
;;;;;;;;;;;;;;;;;;;;;;;;;;;;;;;;;;;;;;;;;;;;;;;;;;;;;;;;;;;;;;;;;;;;;;;;;
defmethod( area (( rt rectTran ))
  if( isCentered(rt) then
    (xCoord(getUpperRight(rt))-xCoord(getLowerLeft(rt))*(yCoord(getUpperRight(rt))-yCoord(getLowerLeft(rt))))
  else
    println("ERROR(rectTran): rectTran is not centered at origin")
  );if
);defMethod

;;;;;;;;;;;;;;;;;;;;;;;;;;;;;;;;;;;;;;;;;;;;;;;;;;;;;;;;;;;;;;;;;;;;;;;;;
; This method translates the recTran about its centroid
;;;;;;;;;;;;;;;;;;;;;;;;;;;;;;;;;;;;;;;;;;;;;;;;;;;;;;;;;;;;;;;;;;;;;;;;;
defmethod( translate (( rt rectTran ) arg )
  let( (urx ury llx lly)
	urx = xCoord(getUpperRight(rt)) + xCoord(arg)
        ury = yCoord(getUpperRight(rt)) + yCoord(arg)
	llx = xCoord(getLowerLeft(rt))  + xCoord(arg)
	lly = yCoord(getLowerLeft(rt))  + yCoord(arg)
	setUpperRight(rt list(urx ury))
	setLowerLeft(rt list(llx lly))
	calculateCentroid(rt)
	;setCentroid(rt list( xCoord(getCentroid(rt))+xCoord(arg) yCoord(getCentroid(rt))+yCoord(arg)))
  );let
);defMethod

;;;;;;;;;;;;;;;;;;;;;;;;;;;;;;;;;;;;;;;;;;;;;;;;;;;;;;;;;;;;;;;;;;;;;;;;;
; Get the vertices from the rectTran
;;;;;;;;;;;;;;;;;;;;;;;;;;;;;;;;;;;;;;;;;;;;;;;;;;;;;;;;;;;;;;;;;;;;;;;;;
defmethod( getVertices (( rt rectTran ))
  let( (v0 v1 v2 v3 v4)
    ;ll
    v0 = getLowerLeft(rt)
    ;lr
    v1 = list( -xCoord(getLowerLeft(rt)) yCoord(getLowerLeft(rt)) )
    ;ur
    v2 = getUpperRight(rt)
    ;ul
    v3 = list( -xCoord(getUpperRight(rt)) yCoord(getUpperRight(rt)) )
    ;ll (closes the polygon)
    v4 = v0
    list(v0 v1 v2 v3 v4)
  );let
);defmethod

;;;;;;;;;;;;;;;;;;;;;;;;;;;;;;;;;;;;;;;;;;;;;;;;;;;;;;;;;;;;;;;;;;;;;;;;;
; This method rotates the rectTran about its centroid
; The rectran's centroid must be centered at origin
; for this to work properly
;;;;;;;;;;;;;;;;;;;;;;;;;;;;;;;;;;;;;;;;;;;;;;;;;;;;;;;;;;;;;;;;;;;;;;;;;
defmethod( rotate (( rt rectTran ) arg )
  let( (poly)
      poly = makeInstance( 'polygon2)
      setVertices(poly getVertices(rt))
      rotate(poly arg)
      setRectTran(poly)
      setUpperRight(rt getUpperRight(poly->rtran))
      setLowerLeft(rt getLowerLeft(poly->rtran))
  );let
);defMethod

;;;;;;;;;;;;;;;;;;;;;;;;;;;;;;;;;;;;;;;;;;;;;;;;;;;;;;;;;;;;;;;;;;;;;;;;;
; This method scales the rectTran about its centroid
;;;;;;;;;;;;;;;;;;;;;;;;;;;;;;;;;;;;;;;;;;;;;;;;;;;;;;;;;;;;;;;;;;;;;;;;;
;defmethod( scale (( rt rectTran ) arg)
;	nil
;);defMethod

;###############################################################################
; render the rectTran
;###############################################################################
defmethod( render (( rt rectTran ))
  if( !null(getUpperRight(rt)) && !null(getLowerLeft(rt)) then
        println("INFO(rectTran): Rendering")
        dbCreateRect(rt->ref
	     	     list(rt->layer rt->purpose)
		     list(getLowerLeft(rt) getUpperRight(rt))
        );dbCreateRect
  else
    println("ERROR(recTran): No UpperRight or LowerLeft Coordinate")
  );if
);defmethod

;;;;;;;;;;;;;;;;;;;;;;;;;;;;;;;;;;;;;;;;;;;;;;;;;;;;;;;;;;;;;;;;;;;;;;;;;
; This method returns the smallest bounding rectangle composed of the
; current bounding rectangle and the bounding rectangle of the input
; rectTran argument
;;;;;;;;;;;;;;;;;;;;;;;;;;;;;;;;;;;;;;;;;;;;;;;;;;;;;;;;;;;;;;;;;;;;;;;;;
defmethod( union (( rt rectTran ) arg)
 let( ( maxx minx maxy miny )
    if( classp(arg 'rectTran) then
      println("INFO(rectran): Performing the union of two rectTrans")
      maxx =  max(xCoord(getUpperRight(rt)) xCoord(getUpperRight(arg)))
      minx =  min(xCoord(getLowerLeft(rt))  xCoord(getLowerLeft(arg)))
      maxy =  max(yCoord(getUpperRight(rt)) yCoord(getUpperRight(arg)))
      miny =  min(yCoord(getLowerLeft(rt))  yCoord(getLowerLeft(arg)))
      setUpperRight(rt list(maxx maxy))
      setLowerLeft(rt list(minx miny))
    else
      println("ERROR(recTran): Rectran object argument required")
    );if
  );let
);defMethod

;;;;;;;;;;;;;;;;;;;;;;;;;;;;;;;;;;;;;;;;;;;;;;;;;;;;;;;;;;;;;;;;;;;;;;;;;
; FIXME: the methods below should be part of a "rectTrans" class that
;        operates on a collection of rectTran objects
;;;;;;;;;;;;;;;;;;;;;;;;;;;;;;;;;;;;;;;;;;;;;;;;;;;;;;;;;;;;;;;;;;;;;;;;;
;;;;;;;;;;;;;;;;;;;;;;;;;;;;;;;;;;;;;;;;;;;;;;;;;;;;;;;;;;;;;;;;;;;;;;;;;
; This method returns the intersection of two class box's object and a
; list of bboxs
;;;;;;;;;;;;;;;;;;;;;;;;;;;;;;;;;;;;;;;;;;;;;;;;;;;;;;;;;;;;;;;;;;;;;;;;;
;defmethod( intersection (( bb bbox ) box)
;  let( (llxList llyList urxList uryList maxllx maxlly minurx minury )
;       llxList = foreach(mapcar bb->bbox box xCoord( lowerLeft( bb->bbox )))
;       llyList = foreach(mapcar bb->bbox box yCoord( lowerLeft( bb->bbox )))
;       urxList = foreach(mapcar bb->bbox box xCoord( upperRight( bb->bbox )))
;       uryList = foreach(mapcar bb->bbox box yCoord( upperRight( bb->bbox )))
;       minurx = apply( 'min urxList )
;       minury = apply( 'min uryList )
;       maxllx = apply( 'max llxList )
;       maxlly = apply( 'max llyList )
;       cond(
;		( maxllx >= minurx
;	  	  nil
;		);maxllx
;		( maxlly >= minury
;	  	  nil
;		);maxlly
;		( t
;	  	  list(maxllx:maxlly minurx:minury)
;		);t
; 	);cond
;  );let
;);defmethod

;;;;;;;;;;;;;;;;;;;;;;;;;;;;;;;;;;;;;;;;;;;;;;;;;;;;;;;;;;;;;;;;;;;;;;;;;
; This Method Shifts The bbox Origin To the Upper Right Quadrant of the
; cellviews master grid field
;;;;;;;;;;;;;;;;;;;;;;;;;;;;;;;;;;;;;;;;;;;;;;;;;;;;;;;;;;;;;;;;;;;;;;;;;
;defmethod( shiftURQ (( bb bbox ))
;  let( ( shift dx dy)
;	  getbBox(bb)
;	  unless( caar( bb->bbox) == 0 && cadar( bb->bbox) == 0
;		  dx = 0 - bb->origin->x
;     		  dy = 0 - bb->origin->y
;      		  shift = list( list( dx dy) "R0")
;      		  printf( "NOTE:  shifting %s to upper-right quadrant" name)
;      		  printf( "       shift is: %f by %f" caar( shift) cadar( shift))
;		  dbReopen( bb->cvRef "a")
;		  foreach( inst cvRef~>instances dbMoveFig( inst bb->cvRef shift))
;    		  foreach( shape cvRef~>shapes   dbMoveFig( shape bb->cvRef shift))
;      		  dbSave(bb->cvRef)
;		  dbClose(bb->cvRef)
;	  );unless
;	  getbBox(bb)
;  );let
;);defMethod

;;;;;;;;;;;;;;;;;;;;;;;;;;;;;;;;;;;;;;;;;;;;;;;;;;;;;;;;;;;;;;;;;;;;;;;;;
; This Method Shifts bbox Origin by provided dx and dy values
;;;;;;;;;;;;;;;;;;;;;;;;;;;;;;;;;;;;;;;;;;;;;;;;;;;;;;;;;;;;;;;;;;;;;;;;;
;defmethod( setCentroid (( bb bbox ) arg)
;  let( ( sx sy )
;  );let
;) ; defMethod

;;;;;;;;;;;;;;;;;;;;;;;;;;;;;;;;;;;;;;;;;;;;;;;;;;;;;;;;;;;;;;;;;;;;;;;;;
; This Method Shifts cellview bbox Origin by provided dx and dy values
;;;;;;;;;;;;;;;;;;;;;;;;;;;;;;;;;;;;;;;;;;;;;;;;;;;;;;;;;;;;;;;;;;;;;;;;;
;defmethod( shiftCentroidCellView (( bb bbox ) dx dy)
;	let( ( (name bb->cellName)
;		   (lib  bb->library)
;		   shift
;		   sx
;                  sy
;		   cvRef )
;		getbBox(bb)
;		cvRef = dbOpenCellViewByType( lib name "layout" "maskLayout")
;		sx = bb->x0 + dx
;      	sy = bb->y0 + dy
;      	shift = list( list( sx sy) "R0")
;		dbReopen( cvRef "a")
;		foreach( inst cvRef~>instances dbMoveFig( inst cvRef shift))
;    	foreach( shape cvRef~>shapes   dbMoveFig( shape cvRef shift))
;      	dbSave(cvRef)
;		dbClose(cvRef)
;		getbBox(bb)
;		)
;) ; defMethod

;;;;;;;;;;;;;;;;;;;;;;;;;;;;;;;;;;;;;;;;;;;;;;;;;;;;;;;;;;;;;;;;;;;;;;;;;;;;;
;;;;;;;;;;;;;;;;;;;;;;;;;;;;;;;;;;;;;;;;;;;;;;;;;;;;;;;;;;;;;;;;;;;;;;;;;;;;;
;;;;;;;;;;;;;;;;;;;;;;;;;;;;;;;;;;;;;;;;;;;;;;;;;;;;;;;;;;;;;;;;;;;;;;;;;;;;;
