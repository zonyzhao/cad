;;;;;;;;;;;;;;;;;;;;;;;;;;;;;;;;;;;;;;;;;;;;;;;;;;;;;;;;;;;;;;;;;;;;;;;;;;;;;;;;
;  cv.ils: Cell view class inheriting from cadObj
;;;;;;;;;;;;;;;;;;;;;;;;;;;;;;;;;;;;;;;;;;;;;;;;;;;;;;;;;;;;;;;;;;;;;;;;;;;;;;;;
;defgeneric( clone (obj arg)
;  error( "Clone is a subclass responsibility\n")
;);defgeneric
;;;;;;;;;;;;;;;;;;;;;;;;;;;;;;;;;;;;;;;;;;;;;;;;;;;;;;;;;;;;;;;;;;;;;;;;;;;;;;;;;
defclass( cv (bbox)
  (
    ( name @reader getName @writer setName )
    ( view @reader getView @writer setView )
    ( lib @reader getLib @writer setLib )
    ( orient @reader getOrient @writer setOrient )
    ( cvLeaf )
    ( cvPcell )
    ( instances )
    ( shapes )
    ( leafs )
    ( leafCells )
    ( stack )
    ( layers )
    ( pcells )
    ( bbx @reader getBbx )
    ( iRefs )
    ( iCnt )
    ( iNames )
    ( iLibNames )
    ( iLevels )
    ( iLayers )
    ( uLayers @reader getuLayers )
  )
);defClass
;;;;;;;;;;;;;;;;;;;;;;;;;;;;;;;;;;;;;;;;;;;;;;;;;;;;;;;;;;;;;;;;;;;;;;;;;
; Class constructor
;;;;;;;;;;;;;;;;;;;;;;;;;;;;;;;;;;;;;;;;;;;;;;;;;;;;;;;;;;;;;;;;;;;;;;;;;
defmethod( initializeInstance @after ((obj cv))
	   obj->name      = nil
	   obj->view      = nil
	   obj->lib       = nil
	   obj->orient    = nil
	   obj->cvLeaf    = nil
           obj->cvPcell   = nil
	   obj->instances = makeInstance('collection)
	   obj->shapes    = makeInstance('collection)
	   obj->leafs     = nil
	   obj->leafCells = makeInstance('collection)
	   obj->layers    = nil
	   obj->stack     = makeInstance('stackup)
	   obj->pcells    = nil
	   obj->bbx       = makeInstance('bbox)
	   obj->iRefs     = nil
	   obj->iCnt      = nil
	   obj->iNames    = nil
	   obj->iLibNames = nil
           obj->iLevels   = nil
	   obj->iLayers   = makeInstance('listfun)
	   obj->uLayers   = nil
	   obj->width     = nil
	   obj->height    = nil
);defmethod
;;;;;;;;;;;;;;;;;;;;;;;;;;;;;;;;;;;;;;;;;;;;;;;;;;;;;;;;;;;;;;;;;;;;;;;;;
; Clones the cellview object
;;;;;;;;;;;;;;;;;;;;;;;;;;;;;;;;;;;;;;;;;;;;;;;;;;;;;;;;;;;;;;;;;;;;;;;;;
defmethod( cloneCv (( cell cv) arg )
  arg->name = cell->name
  arg->view = cell->view
  arg->lib = cell->lib
  arg->orient = cell->orient
  arg->cvLeaf = cell->cvLeaf
  arg->cvPcell = cell->cvPcell
  arg->instances = cell->instances
  arg->leafs = cell->leafs
  arg->leafCells = cell->leafCells
  arg->layers = cell->layers
  arg->stack = cell->stack
  arg->pcells = cell->pcells
  arg->bbx->bbox = cell->bbx->bbox
  arg->iRefs = cell->iRefs
  arg->iCnt = cell->iCnt
  arg->iNames = cell->iNames
  arg->iLibNames = cell->iLibNames
  arg->iLevels = cell->iLevels
  arg->iLayers = cell->iLayers
  arg->uLayers = cell->uLayers
  arg->width = cell->width
  arg->height = cell->height
  cloneBbox(cell arg)
  cloneCadObj(cell arg)
);defmethod
;;;;;;;;;;;;;;;;;;;;;;;;;;;;;;;;;;;;;;;;;;;;;;;;;;;;;;;;;;;;;;;;;;;;;;;;;
; Set cv reference of this and the bbx component
;;;;;;;;;;;;;;;;;;;;;;;;;;;;;;;;;;;;;;;;;;;;;;;;;;;;;;;;;;;;;;;;;;;;;;;;;
;defmethod( setCvRef (( cell cv ) arg)
;     setRef(cell arg)
;     setRef(cell->bbx arg)
;);defmethod
;;;;;;;;;;;;;;;;;;;;;;;;;;;;;;;;;;;;;;;;;;;;;;;;;;;;;;;;;;;;;;;;;;;;;;;;;
; Set origin of cellview
;;;;;;;;;;;;;;;;;;;;;;;;;;;;;;;;;;;;;;;;;;;;;;;;;;;;;;;;;;;;;;;;;;;;;;;;;
;defmethod( setOrigin (( cell cv ) arg)
;  let((orig shx shy)
;     orig  = Origin(cell->bbx)
;     shx = xCoord(arg) - xCoord(orig)
;;     shy = yCoord(arg) - yCoord(orig)
;    shiftOrigin(cell->bbx list(shx shy))
;  );let
;);defmethod
;;;;;;;;;;;;;;;;;;;;;;;;;;;;;;;;;;;;;;;;;;;;;;;;;;;;;;;;;;;;;;;;;;;;;;;;;
; Get origin of cellview
;;;;;;;;;;;;;;;;;;;;;;;;;;;;;;;;;;;;;;;;;;;;;;;;;;;;;;;;;;;;;;;;;;;;;;;;;
;defmethod( getOrigin (( cell cv ))
;  cell->origin = Origin(cell->bbx)
;);defmethod
;;;;;;;;;;;;;;;;;;;;;;;;;;;;;;;;;;;;;;;;;;;;;;;;;;;;;;;;;;;;;;;;;;;;;;;;;
; Checks critical members being non-nil
;;;;;;;;;;;;;;;;;;;;;;;;;;;;;;;;;;;;;;;;;;;;;;;;;;;;;;;;;;;;;;;;;;;;;;;;;
defmethod( checkSettings (( cell cv ))
  let((ret)
    ret = 't
    if(null(getName(cell)) then
      println("Warning cell name not set")
      ret=nil
    );if
    if(null(getName(lib)) then
      println("Warning cell library not set")
      ret=nil
    );if
     if(null(getView(lib)) then
      println("Warning cell view not set")
      ret=nil
    );if
    if(null(getRef(cell)) then
      println("Warning cell reference not set")
      ret=nil
    );if
    ret
  );let
);defmethod
;;;;;;;;;;;;;;;;;;;;;;;;;;;;;;;;;;;;;;;;;;;;;;;;;;;;;;;;;;;;;;;;;;;;;;;;;
; Determines if the cellview has instances (flat if no instances)
;;;;;;;;;;;;;;;;;;;;;;;;;;;;;;;;;;;;;;;;;;;;;;;;;;;;;;;;;;;;;;;;;;;;;;;;;
defmethod( hasInstance (( cell cv ))
  !null(dbHasInstance(getRef(cell)))
);defmethod
;;;;;;;;;;;;;;;;;;;;;;;;;;;;;;;;;;;;;;;;;;;;;;;;;;;;;;;;;;;;;;;;;;;;;;;;;
; Completely flatten (smash) the entire cellview hierarchy
;;;;;;;;;;;;;;;;;;;;;;;;;;;;;;;;;;;;;;;;;;;;;;;;;;;;;;;;;;;;;;;;;;;;;;;;;
defmethod( smash (( cell cv ))
  let((insts n)
    n=1
    insts = getInstances(cell)
    for(i 0 sub1(length(insts))
      inst = nth(i insts)
      dbFlattenInst(inst 32 t)
      i++
    );for
    resetCollection(cell->instances)
    n
  );let
);defmethod
;;;;;;;;;;;;;;;;;;;;;;;;;;;;;;;;;;;;;;;;;;;;;;;;;;;;;;;;;;;;;;;;;;;;;;;;;
; Get all the instances in the current cellview
;;;;;;;;;;;;;;;;;;;;;;;;;;;;;;;;;;;;;;;;;;;;;;;;;;;;;;;;;;;;;;;;;;;;;;;;;
defmethod( getInstances (( cell cv ))
  let( (instances temp)
    instances = cell->ref~>instances
    foreach( inst instances
      temp = makeInstance( 'instance )
      setRef(temp inst)
      add(cell->instances temp)
    );foreach
    instances = cell->ref~>instances
  );let
);defmethod
;;;;;;;;;;;;;;;;;;;;;;;;;;;;;;;;;;;;;;;;;;;;;;;;;;;;;;;;;;;;;;;;;;;;;;;;;
; Synchronizes the instances and shapes of the db cellview to the
; cv object
;;;;;;;;;;;;;;;;;;;;;;;;;;;;;;;;;;;;;;;;;;;;;;;;;;;;;;;;;;;;;;;;;;;;;;;;;
defmethod( synchronize (( cell cv ))
  let((refs temp)
    resetCollection(cell->instances)
    resetCollection(cell->shapes)
    refs = getRef(cell)~>instances
    if(!null(refs) then
      foreach(ref refs
        temp = makeInstance( 'instance )
        setName(cell ref~>cellName)
	setLib(cell ref~>libName)
	setView(cell ref~>view)
	add(cell->instances temp)
      );foreach
    );if
    refs = getRef(cell)~>shapes
    if(!null(refs) then
      foreach(ref refs
      	if(ref~>isShape then
          temp = makeInstance( 'shape )
	  temp->transform->vertices = ref~>points
          setType(temp ref~>objType)
	  setLayer(temp ref~>layerName)
	  setNumber(temp ref~>layerNum)
	  setPurpose(temp yCoord(ref~>lpp))
	  setNumVertices(temp ref~>nPoints)
	  add(cell->shapes temp)
        );if
      );foreach
    );if
  );let
);defmethod
;;;;;;;;;;;;;;;;;;;;;;;;;;;;;;;;;;;;;;;;;;;;;;;;;;;;;;;;;;;;;;;;;;;;;;;;;
; Delete all instances in the current cellview
; FIXME: might want a checksum between db and object here
;        it can be corrected here to ...
;;;;;;;;;;;;;;;;;;;;;;;;;;;;;;;;;;;;;;;;;;;;;;;;;;;;;;;;;;;;;;;;;;;;;;;;;
defmethod( deleteAllInstances (( cell cv ))
  let((instances refs i)
    synchronize(cell)
    instances = getInstances(cell)
    refs = getRef(cell)~>instances
    if(!null(refs) then
      i=0
      ; delete from instances from the db cellview
      foreach(ref refs
        dbDeleteObject(ref)
        i++
      );foreach
      printf("INFO: Deleted %d cellview instances.\n" i)
    );if
    refs = getRef(cell)~>shapes
    if(!null(refs) then
      i=0
      ; delete from shapes from the db cellview
      foreach(ref refs
        dbDeleteObject(ref)
        i++
      );foreach
      printf("INFO: Deleted %d cellview shapes.\n" i)
    );if
    ; delete from the object
    if(!null(instances) then
      i=0
      foreach(inst instances
        removeItem(cell->instances inst)
	i++
      );foreach
      printf("INFO: Deleted %d cell object instances.\n" i)
    );if
  );let
);defmethod
;;;;;;;;;;;;;;;;;;;;;;;;;;;;;;;;;;;;;;;;;;;;;;;;;;;;;;;;;;;;;;;;;;;;;;;;;
; Create a new instance in the cellview
; FIXME: Create and container of instances
; FIXME: How is this even working!! cv->ref should be getRef(cell)
; FIXME: If i try to fix this skill++ won't load into cad61 session.
;        Don't know why - xyn crises so no time to debug!!
;;;;;;;;;;;;;;;;;;;;;;;;;;;;;;;;;;;;;;;;;;;;;;;;;;;;;;;;;;;;;;;;;;;;;;;;;
defmethod( createInstance (( cell cv ) inst )
  add(cell->instances dbCreateInst( inst getRef(cell) nil 0:0 "R0" 1) )
);defmethod
;;;;;;;;;;;;;;;;;;;;;;;;;;;;;;;;;;;;;;;;;;;;;;;;;;;;;;;;;;;;;;;;;;;;;;;;;
; Create a new instance in the cellview
; FIXME: Create and container of instances
; FIXME: If i try to fix this skill++ won't load into cad61 session.
;        Don't know why - xyn crises so no time to debug!!
;;;;;;;;;;;;;;;;;;;;;;;;;;;;;;;;;;;;;;;;;;;;;;;;;;;;;;;;;;;;;;;;;;;;;;;;;
defmethod( copyInstance (( cell cv ) arg )
  let((inst temp)
    inst = dbCopyFig(arg getRef(cell) list(0:0 "R0" 1))
    if(dbIsId(inst) then
      temp = makeInstance( 'instance )
      setRef(temp inst)
      setName(temp inst~>cellName)
      setLib(temp inst~>libName)
      setView(temp inst~>viewName)
      add(cell->instances temp)
    else
      printf("ERROR: No Instance ID. Instance not copied to cellview: %s"  temp inst~>cellName);
      nil
    );if
  );let
);defmethod
;;;;;;;;;;;;;;;;;;;;;;;;;;;;;;;;;;;;;;;;;;;;;;;;;;;;;;;;;;;;;;;;;;;;;;;;;
; Create a new instance in the cellview
; version used in reticle builder
; FIXME: need to create a new instance object and add this to the instance collection
;;;;;;;;;;;;;;;;;;;;;;;;;;;;;;;;;;;;;;;;;;;;;;;;;;;;;;;;;;;;;;;;;;;;;;;;;
defmethod( createInstance2 (( cell cv ) inst name orig orient)
  dbCreateInst( getRef(cell) inst name orig orient 1)
);defmethod
;;;;;;;;;;;;;;;;;;;;;;;;;;;;;;;;;;;;;;;;;;;;;;;;;;;;;;;;;;;;;;;;;;;;;;;;;
; This Method Gets Cell Grid Information
;;;;;;;;;;;;;;;;;;;;;;;;;;;;;;;;;;;;;;;;;;;;;;;;;;;;;;;;;;;;;;;;;;;;;;;;;
defmethod( getGridInfo (( cell cv ))
		dbGetGlobalGridOffsetReferenceType(cell->ref)
		dbGetGlobalGridDefaultRepeatMode(cell->ref)
		dbGetGlobalGridRepeatMode(cell->ref "wsspDefName" "wspName")
);defmethod
;;;;;;;;;;;;;;;;;;;;;;;;;;;;;;;;;;;;;;;;;;;;;;;;;;;;;;;;;;;;;;;;;;;;;;;;;
; Removes layout cell from library
;;;;;;;;;;;;;;;;;;;;;;;;;;;;;;;;;;;;;;;;;;;;;;;;;;;;;;;;;;;;;;;;;;;;;;;;;
defmethod( removeCell (( cell cv ))
		let( ( (name cell->name)
		       (lib  cell->lib) )
		if( !null(ddGetObj(cell->lib cell->name cell->view)) then
		    if(!null(ddDeleteObj(ddGetObj(cell->lib cell->name cell->view))) then
		      printf("INFO: Removing cell view: %s\n" cell->name)
		      t
		    else
		      printf("ERROR: Could not deleted cell view: %s\n" cell->name)
		      nil
		    );if
		else
	            printf("ERROR: Cell view not found: %s\n" cell->name)
		    nil
                );if
	); let
);defmethod
;;;;;;;;;;;;;;;;;;;;;;;;;;;;;;;;;;;;;;;;;;;;;;;;;;;;;;;;;;;;;;;;;;;;;;;;;
; Copys layout view to another name in the same library
;;;;;;;;;;;;;;;;;;;;;;;;;;;;;;;;;;;;;;;;;;;;;;;;;;;;;;;;;;;;;;;;;;;;;;;;;
defmethod( Copy (( cell cv ) name)
  let((cv cpCv)
    cv = getRef(cell)
    if( null(ddGetObj(cell->lib name cell->view )) then
      println("INFO(cv): Copying cellview")
      cpCv = dbCopyCellView(cv cell->lib name cell->view "" nil t)
      dbSave( cpCv )
      dbClose( cpCv )
      't
    else
      printf("ERROR: layout cell %s exists in library\n" name)
      nil
    );if
  );let
);defmethod
;;;;;;;;;;;;;;;;;;;;;;;;;;;;;;;;;;;;;;;;;;;;;;;;;;;;;;;;;;;;;;;;;;;;;;;;;
; Copies layout view from another library into the cell object's library
;;;;;;;;;;;;;;;;;;;;;;;;;;;;;;;;;;;;;;;;;;;;;;;;;;;;;;;;;;;;;;;;;;;;;;;;;
defmethod( copyCell (( cell cv ) copyLib copyCell)
  if( !ddGetObj(copyLib copyCell "layout") then
    dbCopyCellView(cell->ref copyLib copyCell "layout" "" nil t)
  else
    printf("ERROR: layout cell %s exists in library\n" copyCell)
    nil
  );if
);defmethod
;;;;;;;;;;;;;;;;;;;;;;;;;;;;;;;;;;;;;;;;;;;;;;;;;;;;;;;;;;;;;;;;;;;;;;;;;
; Creates a new cell in the target library
;;;;;;;;;;;;;;;;;;;;;;;;;;;;;;;;;;;;;;;;;;;;;;;;;;;;;;;;;;;;;;;;;;;;;;;;;
defmethod( createCell (( cell cv ))
	let( ( (name cell->name)
		       (lib  cell->lib)
		       cv)
		if( !ddGetObj(lib name "layout") then
		    cv = dbOpenCellViewByType( lib name "layout" "maskLayout" "w")
		    dbSave(cv)
		    dbClose(cv)
		    t
		else
		    printf("ERROR: layout cell %s exists in library\n" name)
		    nil
		);if
	); let
);defmethod
;;;;;;;;;;;;;;;;;;;;;;;;;;;;;;;;;;;;;;;;;;;;;;;;;;;;;;;;;;;;;;;;;;;;;;;;;
; Copies a cellview instance into the a new cell in the target library
; at the origin of the object's cellview
;;;;;;;;;;;;;;;;;;;;;;;;;;;;;;;;;;;;;;;;;;;;;;;;;;;;;;;;;;;;;;;;;;;;;;;;;
defmethod( newCellInstance (( cell cv ) instLib instCell)
	let( ( (name cell->name)
		       (lib  cell->lib)
		       (chlst  cell->children)
		       cvp
                       cvc)
		if( ddGetObj(lib name "layout") then
		    cvp = dbOpenCellViewByType( lib name "layout" "maskLayout" "w")
		    if( ddGetObj(instLib instCell "layout") then
		    	cvc = dbOpenCellViewByType(instLib instCell "layout" "maskLayout")
			;FIXME: need a constructor which provides an initial empty list for children member
                        ;       append this child to the children list list
			cons( child = dbCreateInst( cvp cvc nil 0:0 "R0" 1) chlst )
		    	dbSave(cvp)
			dbClose(cvp)
			dbClose(cvc)
		    	t
	             else
			printf("ERROR: layout cell %s exists in library %s" instCell instLib)
		    	nil
		    );if
		else
		   printf("ERROR: layout cell %s exists in library %s" name lib)
		   nil
		);if
	); let
);defmethod
;;;;;;;;;;;;;;;;;;;;;;;;;;;;;;;;;;;;;;;;;;;;;;;;;;;;;;;;;;;;;;;;;;;;;;;;;
; This method determines if the cv is a leaf cell
; returns t if it is and nil if it is not
;;;;;;;;;;;;;;;;;;;;;;;;;;;;;;;;;;;;;;;;;;;;;;;;;;;;;;;;;;;;;;;;;;;;;;;;;
defmethod( isLeaf (( cell cv ))
   if( length(cell->ref~>instances) > 0 then
     nil
   else
     t
   )
);defmethod
;;;;;;;;;;;;;;;;;;;;;;;;;;;;;;;;;;;;;;;;;;;;;;;;;;;;;;;;;;;;;;;;;;;;;;;;;
; This method determines if the cv is a Pcell
; returns t if it is and nil if it is not
;;;;;;;;;;;;;;;;;;;;;;;;;;;;;;;;;;;;;;;;;;;;;;;;;;;;;;;;;;;;;;;;;;;;;;;;;
defmethod( isPcell (( cell cv ))
   if( length(cell->ref~>instances) > 0 then
     nil
   else
     t
   )
);defmethod
;;;;;;;;;;;;;;;;;;;;;;;;;;;;;;;;;;;;;;;;;;;;;;;;;;;;;;;;;;;;;;;;;;;;;;;;;
; Get cv bbox
;;;;;;;;;;;;;;;;;;;;;;;;;;;;;;;;;;;;;;;;;;;;;;;;;;;;;;;;;;;;;;;;;;;;;;;;;
defmethod( getbBox (( cell cv ))
  setRef(cell->bbx cell->ref)
  getbb(cell->bbx)
);defmethod
;;;;;;;;;;;;;;;;;;;;;;;;;;;;;;;;;;;;;;;;;;;;;;;;;;;;;;;;;;;;;;;;;;;;;;;;;
; Get cv bbox
;;;;;;;;;;;;;;;;;;;;;;;;;;;;;;;;;;;;;;;;;;;;;;;;;;;;;;;;;;;;;;;;;;;;;;;;;
;defmethod( getDim (( cell cv ))
;  setRef(cell->bbx getRef(cell))
;  getDim(cell->bbx)
;  cell->origin = Origin(cell->bbx)
;  cell->width  = getWidth(cell->bbx)
;  cell->height = getHeight(cell->bbx)
;);defmethod
;;;;;;;;;;;;;;;;;;;;;;;;;;;;;;;;;;;;;;;;;;;;;;;;;;;;;;;;;;;;;;;;;;;;;;;;;
;
;;;;;;;;;;;;;;;;;;;;;;;;;;;;;;;;;;;;;;;;;;;;;;;;;;;;;;;;;;;;;;;;;;;;;;;;;
;defmethod( setDim (( cell cv ))
;  getDim(cell->bbx)
;  cell->origin = Origin(cell->bbx)
;  cell->width  = getWidth(cell->bbx)
;  cell->height = getHeight(cell->bbx)
;);defmethod
;;;;;;;;;;;;;;;;;;;;;;;;;;;;;;;;;;;;;;;;;;;;;;;;;;;;;;;;;;;;;;;;;;;;;;;;;
; Helper method for the getTree method
; Get cv recursive instance tree
;;;;;;;;;;;;;;;;;;;;;;;;;;;;;;;;;;;;;;;;;;;;;;;;;;;;;;;;;;;;;;;;;;;;;;;;;
defmethod( getRecursiveTree (( cell cv ) @key cv cLst)
  prog( (instRef llist rlist lc ic)
       cLst = cons(cv cLst)
       if(!null(cv~>instances) then
         if( length(cv~>instances) > 0 then
           llist = '()
	   rlist = '()
       	   foreach( instance cv~>instances
	     printf("Sniffing ID->[%L]: CV->%s: INST->%s(%s)\n" instance cv~>cellName instance~>cellName instance~>name)
	     instRef = dbOpenCellViewByType(instance~>libName instance~>cellName "layout" "maskLayout")
	     ic = makeInstance( 'cv )
	     setName(ic cv~>cellName)
	     setLib(ic cv~>libName)
	     setBbox(ic->bbx cv~>bBox)
	     add(cell->instances ic)
             rlist = cons(getRecursiveTree(cell ?cv instRef ?cLst llist) rlist)
	     ;dbClose(instRef)
	   );foreach
	   return(cons(rlist cLst))
         else
           printf("INFO: Leaf Cell: ID->[%L]: %s\n" cv cv~>cellName)
	   lc = makeInstance( 'cv )
	   setName(lc cv~>cellName)
	   setLib(lc cv~>libName)
	   setBbox(lc->bbx cv~>bBox)
	   add(cell->leafCells lc)
           return(cv)
         );if
       else
         printf("INFO: Leaf cell: ID->[%L] %s\n" cv cv~>cellName)
	 lc = makeInstance( 'cv )
	 setName(lc cv~>cellName)
	 setLib(lc cv~>libName)
	 setBbox(lc->bbx cv~>bBox)
	 add(cell->leafCells lc)
	 return(cv)
       );if
  );prog
);defmethod
;;;;;;;;;;;;;;;;;;;;;;;;;;;;;;;;;;;;;;;;;;;;;;;;;;;;;;;;;;;;;;;;;;;;;;;;;
; Get cv instance tree
; populates the leafCell collection
;;;;;;;;;;;;;;;;;;;;;;;;;;;;;;;;;;;;;;;;;;;;;;;;;;;;;;;;;;;;;;;;;;;;;;;;;
defmethod( getTree (( cell cv ))
  cell->iRefs = '()
  cell->iRefs = getRecursiveTree(cell ?cv cell->ref ?cLst '())
);
;;;;;;;;;;;;;;;;;;;;;;;;;;;;;;;;;;;;;;;;;;;;;;;;;;;;;;;;;;;;;;;;;;;;;;;;;
; Helper Method for printTree method
; Auxilliary Print cv instance tree
;;;;;;;;;;;;;;;;;;;;;;;;;;;;;;;;;;;;;;;;;;;;;;;;;;;;;;;;;;;;;;;;;;;;;;;;;
defmethod( printRecursiveTree (( cell cv ) @key hlist nlev cnt)
    prog( (revlist plist)
  	nlev++
	if( listp(hlist) then
	  revlist = reverse(hlist)
	  if( !listp(nth(0 revlist)) && listp(nth(1 revlist)) then
	    plist = nth(0 cdr(revlist))
	    printf("%s NUMBER OF CELLVIEW INSTANCES: %d\n" nth(0 revlist)~>libName length(plist))
	    for(i 0 sub1(length(plist))
	    	if(listp(nth(i plist)) then
		  printf("L%d: %s INST %d (ROOT) : %s, " sub1(nlev) nth(0 revlist)~>libName i nth(0 reverse(nth(i plist)))~>libName)
		else
	          printf("L%d: %s INST %d : %s" sub1(nlev) nth(0 revlist)~>cellName i nth(i plist)~>libName)
		);if
	        cnt = printRecursiveTree(cell ?hlist nth(i plist) ?nlev nlev ?cnt 0) + cnt
	    );for
	    return(cnt)
	   else
	     printf("HLeaf Cell: %s\n"  nth(0 hlist)~>cellName)
	     return(cnt)
	   );if
	else
	   cnt++
	   printf(" (LEAF)\n")
	   return(cnt)
	);if
  );prog
);
;;;;;;;;;;;;;;;;;;;;;;;;;;;;;;;;;;;;;;;;;;;;;;;;;;;;;;;;;;;;;;;;;;;;;;;;;
; Prints recursive Instance Tree (Uses Auxilliary method " printRecursiveTree"
;;;;;;;;;;;;;;;;;;;;;;;;;;;;;;;;;;;;;;;;;;;;;;;;;;;;;;;;;;;;;;;;;;;;;;;;;
defmethod( printTree (( cell cv ))
  cell->iCnt = 0
  cell->iCnt = printRecursiveTree(cell ?hlist cell->iRefs ?nlev 0 ?cnt 0)
);
;;;;;;;;;;;;;;;;;;;;;;;;;;;;;;;;;;;;;;;;;;;;;;;;;;;;;;;;;;;;;;;;;;;;;;;;;
; Helper Method for getTreeNames method
; Auxilliary Get the instance names of the cv (recursive)
;;;;;;;;;;;;;;;;;;;;;;;;;;;;;;;;;;;;;;;;;;;;;;;;;;;;;;;;;;;;;;;;;;;;;;;;;
defmethod( getRecursiveTreeNames (( cell cv ) @key hlist nlev nList)
  prog( (revlist plist)
  	nlev++
	if( listp(hlist) then
	  revlist = reverse(hlist)
	  if( !listp(nth(0 revlist)) && listp(nth(1 revlist)) then
	    nList = cons(nth(0 revlist)~>cellName nList)
	    plist = nth(0 cdr(revlist))
	    for(i 0 sub1(length(plist))
	        nList = cons(getRecursiveTreeNames(cell ?hlist nth(i plist) ?nlev nlev ?nList '()) nList)
	    );for
	    return(nList)
	   else
	     nList = cons(nth(0 hlist)~>cellName nList)
	     return(nList)
	   );if
	else
	   nList = cons(hlist~>cellName nList)
	   return(nList)
	);if
  );prog
);
;;;;;;;;;;;;;;;;;;;;;;;;;;;;;;;;;;;;;;;;;;;;;;;;;;;;;;;;;;;;;;;;;;;;;;;;;
; Gets recursive Instance Tree Names (Uses  auxilliary method "getRecursiveTreeNames"
;;;;;;;;;;;;;;;;;;;;;;;;;;;;;;;;;;;;;;;;;;;;;;;;;;;;;;;;;;;;;;;;;;;;;;;;;
defmethod( getTreeNames (( cell cv ))
  cell->iNames = ()
  cell->iNames = reverse(getRecursiveTreeNames(cell ?hlist cell->iRefs ?nlev 0 ?nList '()))
);
;;;;;;;;;;;;;;;;;;;;;;;;;;;;;;;;;;;;;;;;;;;;;;;;;;;;;;;;;;;;;;;;;;;;;;;;;
; Auxilliary Get the instance names of the cv (recursive)
;;;;;;;;;;;;;;;;;;;;;;;;;;;;;;;;;;;;;;;;;;;;;;;;;;;;;;;;;;;;;;;;;;;;;;;;;
defmethod( getRecursiveLibTreeNames (( cell cv ) @key hlist nlev nList)
  prog( (revlist plist)
  	nlev++
	if( listp(hlist) then
	  revlist = reverse(hlist)
	  if( !listp(nth(0 revlist)) && listp(nth(1 revlist)) then
	    nList = cons(nth(0 revlist)~>libName nList)
	    plist = nth(0 cdr(revlist))
	    for(i 0 sub1(length(plist))
	        nList = cons(getRecursiveLibTreeNames(cell ?hlist nth(i plist) ?nlev nlev ?nList '()) nList)
	    );for
	    return(nList)
	   else
	     nList = cons(nth(0 hlist)~>libName nList)
	     return(nList)
	   );if
	else
	   nList = cons(hlist~>libName nList)
	   return(nList)
	);if
  );prog
);
;;;;;;;;;;;;;;;;;;;;;;;;;;;;;;;;;;;;;;;;;;;;;;;;;;;;;;;;;;;;;;;;;;;;;;;;;
; Gets recursive Instance Tree Names (Uses  auxilliary method "getRecursiveTreeNames"
;;;;;;;;;;;;;;;;;;;;;;;;;;;;;;;;;;;;;;;;;;;;;;;;;;;;;;;;;;;;;;;;;;;;;;;;;
defmethod( getLibTreeNames (( cell cv ))
  cell->iLibNames = ()
  cell->iLibNames = reverse(getRecursiveLibTreeNames(cell ?hlist cell->iRefs ?nlev 0 ?nList '()))
);
;;;;;;;;;;;;;;;;;;;;;;;;;;;;;;;;;;;;;;;;;;;;;;;;;;;;;;;;;;;;;;;;;;;;;;;;;
; Get the layers used in the cv
; (use list remove() function to filter out repeated layers - lstFun??)
;;;;;;;;;;;;;;;;;;;;;;;;;;;;;;;;;;;;;;;;;;;;;;;;;;;;;;;;;;;;;;;;;;;;;;;;;
defmethod( getLpps (( cell cv ) @key cv cLst)
  prog( (instRef rlist)
       if(!null(cv~>instances) then
         if( length(cv~>instances) > 0 then
	   rlist = '()
       	   foreach( instance cv~>instances
	     printf("Sniffing ID->[%L]: CV->%s: INST->%s(%s)\n" instance cv~>cellName instance~>cellName instance~>name)
	     instRef = dbOpenCellViewByType(instance~>libName instance~>cellName "layout" "maskLayout")
	     if(!null(instRef)  then
	        rlist = cons(getLpps(cell ?cv instRef ?cLst '()) rlist)
	     else
		printf("WARNING: cellview instance not found!")
	     );if
	   );foreach
	   return(cons(rlist cLst))
         else
	   if(!null(cv~>cellName) then
             printf("Leaf Cell: ID->[%L]: %s\n" cv cv~>cellName)
	     foreach( lpp cv~>lpps
	   	 printf("Leaf Cell Layer: %s: %s\n" cv lpp~>layerName)
		 if(!null(lpp~>layerName) then
		   rlist = cons(lpp~>layerName rlist)
                 else
		   return(rlist)
		 );if
	     );foreach
             return(rlist)
	   else
	     printf("WARNING: Cell View not found!")
	     return(rlist)
           ):if
         );if
      else
         if(!null(cv~>cellName) then
           printf("INFO (getLpps): No cellview instances found - leaf cell: %s\n" cv~>cellName)
	   foreach( lpp cv~>lpps
	   	 printf("Leaf Cell Layer: %s: %s\n" cv lpp~>layerName)
		 if(!null(lpp~>layerName) then
		   rlist = cons(lpp~>layerName rlist)
		 else
		   return(rlist)
		 );if
	   );foreach
	   return(rlist)
	  else
	    printf("WARNING: Cell View not found!")
	    return(rlist)
          );if
      );if
  );prog
);
;;;;;;;;;;;;;;;;;;;;;;;;;;;;;;;;;;;;;;;;;;;;;;;;;;;;;;;;;;;;;;;;;;;;;;;;;
; Get the layers in the cv
;;;;;;;;;;;;;;;;;;;;;;;;;;;;;;;;;;;;;;;;;;;;;;;;;;;;;;;;;;;;;;;;;;;;;;;;;
defmethod( getLayers (( cell cv ))
  cell->layers = getLpps( cell ?cv cell->ref ?cLst '())
);
;;;;;;;;;;;;;;;;;;;;;;;;;;;;;;;;;;;;;;;;;;;;;;;;;;;;;;;;;;;;;;;;;;;;;;;;;
; Get the layers used in the cv
; (use list remove() function to filter out repeated layers )
;;;;;;;;;;;;;;;;;;;;;;;;;;;;;;;;;;;;;;;;;;;;;;;;;;;;;;;;;;;;;;;;;;;;;;;;;
defmethod( getUsedLayers (( cell cv ))
    getLayers(cell)
    setElems(cell->iLayers cell->layers)
    flattenRecursive(cell->iLayers)
    cell->uLayers = removeRedundant(cell->iLayers)
    cell->uLayers
);
;;;;;;;;;;;;;;;;;;;;;;;;;;;;;;;;;;;;;;;;;;;;;;;;;;;;;;;;;;;;;;;;;;;;;;;;;
; Gets the technology layer stackup from the target cellview
;;;;;;;;;;;;;;;;;;;;;;;;;;;;;;;;;;;;;;;;;;;;;;;;;;;;;;;;;;;;;;;;;;;;;;;;;
defmethod( getStackUp (( cell cv ))
    setRef(cell->stack cell->ref)
    getStackUp(cell->stack)
);
;;;;;;;;;;;;;;;;;;;;;;;;;;;;;;;;;;;;;;;;;;;;;;;;;;;;;;;;;;;;;;;;;;;;;;;;;
; Create a snapshot using a currently targeted smashed (fully flattened)
; cellview object reference. Argument is a freshly opened layout cellview
; reference.
;;;;;;;;;;;;;;;;;;;;;;;;;;;;;;;;;;;;;;;;;;;;;;;;;;;;;;;;;;;;;;;;;;;;;;;;;
defmethod( snapshot (( cell cv ))
    setRef(cell->stack cell->ref)
    renderStack(cell->stack)
);
;;;;;;;;;;;;;;;;;;;;;;;;;;;;;;;;;;;;;;;;;;;;;;;;;;;;;;;;;;;;;;;;;;;;;;;;;
; Removes layers from the stackup object
;;;;;;;;;;;;;;;;;;;;;;;;;;;;;;;;;;;;;;;;;;;;;;;;;;;;;;;;;;;;;;;;;;;;;;;;;
defmethod(  removeLayerFromStackup (( cell cv ) arg)
    deleteLayer(cell->stack arg)
);
;;;;;;;;;;;;;;;;;;;;;;;;;;;;;;;;;;;;;;;;;;;;;;;;;;;;;;;;;;;;;;;;;;;;;;;;;
; Prints the stackup layer contents
;;;;;;;;;;;;;;;;;;;;;;;;;;;;;;;;;;;;;;;;;;;;;;;;;;;;;;;;;;;;;;;;;;;;;;;;;
defmethod(  printStackUp (( cell cv ))
    printStackUp(cell->stack)
);

;;;;;;;;;;;;;;;;;;;;;;;;;;;;;;;;;;;;;;;;;;;;;;;;;;;;;;;;;;;;;;;;;;;;;;;;;
; Get the leaf cells used in the cv
;;;;;;;;;;;;;;;;;;;;;;;;;;;;;;;;;;;;;;;;;;;;;;;;;;;;;;;;;;;;;;;;;;;;;;;;;
defmethod( getLeafCells (( cell cv ))
  cell->leafCells->list->elems
);
;;;;;;;;;;;;;;;;;;;;;;;;;;;;;;;;;;;;;;;;;;;;;;;;;;;;;;;;;;;;;;;;;;;;;;;;;
; Get the pcells used in the cv
;;;;;;;;;;;;;;;;;;;;;;;;;;;;;;;;;;;;;;;;;;;;;;;;;;;;;;;;;;;;;;;;;;;;;;;;;
defmethod( getPcells (( cell cv ))
    nil
);
;;;;;;;;;;;;;;;;;;;;;;;;;;;;;;;;;;;;;;;;;;;;;;;;;;;;;;;;;;;;;;;;;;;;;;;;;
;  Close and purge the cv
;;;;;;;;;;;;;;;;;;;;;;;;;;;;;;;;;;;;;;;;;;;;;;;;;;;;;;;;;;;;;;;;;;;;;;;;;
defmethod( closeAndPurge (( cell cv ))
    cell->ref = dbOpenCellViewByType( cell->lib cell->name cell->view "maskLayout")
    if(!null(cell->ref) then
      if( !null(dbPurge(cell->ref)) then
        printf("INFO: Closing and Purging: %s\n:" cell->name )
      else
        printf("WARNING: Cellview not found: %s\n:" cell->name )
      );if
    else
      printf("WARNING: Cellview not found: %s\n:" cell->name )
    );if
);
;;;;;;;;;;;;;;;;;;;;;;;;;;;;;;;;;;;;;;;;;;;;;;;;;;;;;;;;;;;;;;;;;;;;;;;;;
;  "Cleans" up a list of cellviews. Open's, closes, purges and then
;   deletes the list of cellviews in the input argument list.
;   Cellview list must be in the same library as the current cv object's
;   cellview member as determined by the cv->lib member.
;;;;;;;;;;;;;;;;;;;;;;;;;;;;;;;;;;;;;;;;;;;;;;;;;;;;;;;;;;;;;;;;;;;;;;;;;
defmethod( clean (( cell cv ) arg )
  let( (cvName)
           cvName = cell->name
	   foreach( ar arg
	     cell->name = ar
	     closeAndPurge(cell)
	   );foreach
	   cell->name = cvName
  );let
);defmethod
;;;;;;;;;;;;;;;;;;;;;;;;;;;;;;;;;;;;;;;;;;;;;;;;;;;;;;;;;;;;;;;;;;;;;;;;;
; This method recursively finds all the instances of the given name in
; a cellview heirarchy (See reference procedure in test.il)
; FIXME: Refer to tree view recursive behavior above to get the
;        recursion right in this method
;;;;;;;;;;;;;;;;;;;;;;;;;;;;;;;;;;;;;;;;;;;;;;;;;;;;;;;;;;;;;;;;;;;;;;;;;
;defmethod( getAllInstances (( cell cv ) name @optional (transform list(0:0 "R0" 1))
;  let( (localCellInfo globalCellInfo iname)
;    localCellInfo = '()
;    iname = lowerCase(name)
;    foreach(inst cv~>instances
;      when(inst~>objType=="inst"
;	printf("Checking instance: %s\n" inst~>cellName)
;	if(rexMatchp(iname lowerCase(inst~>cellName)) then
;	  InternalCellInfo = list(inst~>cellName  dbTransformPoint(inst~>xy transform) inst~>orient)
;	  globalCellInfo = cons(InternalCellInfo GLOBAL_INST)
;	  printf("Adding %s to list" inst~>cellName)
;	);if
;	getAllInstances(cv inst~>master iname dbConcatTransform(inst~>transform transform) strcat(hierInstPath inst~>cellName "/"))
;      );while
;    );foreach
;    t
;  );let
;);defmethod
;;;;;;;;;;;;;;;;;;;;;;;;;;;;;;;;;;;;;;;;;;;;;;;;;;;;;;;;;;;;;;;;;;;;;;;;;
; Gets recursive Instance Tree Names (Uses  auxilliary method "getRecursiveTreeNames"
;;;;;;;;;;;;;;;;;;;;;;;;;;;;;;;;;;;;;;;;;;;;;;;;;;;;;;;;;;;;;;;;;;;;;;;;;
defmethod( isCell (( cell cv))
  let((cv)
    if(!null(ddGetObj(cell->lib cell->name cell->view )) then
      cv = dbOpenCellViewByType( cell->lib cell->name cell->view "" nil)
      if(dbIsId(cv) then
         printf("INFO(cv): Cellview %s has valid library and cellview IDs.\n" cell->name)
         t
      else
        printf("ERROR(cv): Cellview %s does not have a valid library ID (purge state?).\n" cell->name)
        ;FIXME: Attempt to clear purge state with a dbSave() and dbClose()??
	println("INFO(cv): Attempting to fix a potential purged state issue ...")
	dbSave(cv)
	dbClose(cv)
	cv = dbOpenCellViewByType( cell->lib cell->name cell->view "" nil)
	if(dbIsId(cv) then
	  printf("INFO(cv): Cellview %s has valid library and cellview IDs.\n" cell->name)
          t
	else
          printf("ERROR(cv): Cellview %s does not have a valid library ID.\n" cell->name)
	  nil
        );if
      );if
      dbClose(cv)
     else
      nil
    );if
  );let
);defmethod

;;;;;;;;;;;;;;;;;;;;;;;;;;;;;;;;;;;;;;;;;;;;;;;;;;;;;;;;;;;;;;;;;;;;;;;;;;;;;
;;;;;;;;;;;;;;;;;;;;;;;;;;;;;;;;;;;;;;;;;;;;;;;;;;;;;;;;;;;;;;;;;;;;;;;;;;;;;
;;;;;;;;;;;;;;;;;;;;;;;;;;;;;;;;;;;;;;;;;;;;;;;;;;;;;;;;;;;;;;;;;;;;;;;;;;;;;
