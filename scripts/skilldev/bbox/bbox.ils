;;;;;;;;;;;;;;;;;;;;;;;;;;;;;;;;;;;;;;;;;;;;;;;;;;;;;;;;;;;;;;;;;;;;;;;;;;;;;;;;
;;;;;;;;;;;;;;;;  bbox.ils: Boundary Box Class
;;;;;;;;;;;;;;;;;;;;;;;;;;;;;;;;;;;;;;;;;;;;;;;;;;;;;;;;;;;;;;;;;;;;;;;;;;;;;;;;
defclass( bbox (cadObj)
  (
    ( ur @reader getUr @writer setUr )
    ( ll @reader getLl @writer setLl )
    ( width @reader getWidth @writer setWidth )
    ( height @reader getHeight @writer setHeight )
    ( bbox @reader getBbox @writer setBbox)
    ( origin @reader getOrigin @writer setOrigin)
    ( centroid @reader getCentroid @writer setCentroid)
    ( vertices @reader getVertices @writer setVertices)
    ( transformation @reader getTrans)
  )
);defClass
;#####################################################
; Constructor method
;#####################################################
defmethod( initializeInstance @after ((obj bbox))
  obj->ur = nil
  obj->ll = nil
  obj->width = nil
  obj->height = nil
  obj->bbox = nil
  obj->origin = nil
  obj->centroid = nil
  obj->vertices = '()
  obj->transformation = makeInstance( 'transformation2 )
);defmethod
;;;;;;;;;;;;;;;;;;;;;;;;;;;;;;;;;;;;;;;;;;;;;;;;;;;;;;;;;;;;;;;;;;;;;;;;;
; Clones the cellview object
;;;;;;;;;;;;;;;;;;;;;;;;;;;;;;;;;;;;;;;;;;;;;;;;;;;;;;;;;;;;;;;;;;;;;;;;;
defmethod( cloneBbox (( bb bbox) arg )
  arg->ur     = bb->ur
  arg->ll     = bb->ll
  arg->width  = bb->width
  arg->height = bb->height
  arg->origin = bb->origin
  arg->bbox   = bb->bbox
);defmethod
;;;;;;;;;;;;;;;;;;;;;;;;;;;;;;;;;;;;;;;;;;;;;;;;;;;;;;;;;;;;;;;;;;;;;;;;;
; This Method Populates Boundary Box Member with the contents of the
; reference cv's boundary box
;;;;;;;;;;;;;;;;;;;;;;;;;;;;;;;;;;;;;;;;;;;;;;;;;;;;;;;;;;;;;;;;;;;;;;;;;
defmethod( getbb (( bb bbox ))
	setBbox(bb getRef(bb)~>bBox)
);defMethod
;;;;;;;;;;;;;;;;;;;;;;;;;;;;;;;;;;;;;;;;;;;;;;;;;;;;;;;;;;;;;;;;;;;;;;;;;
; This Method sets the cv bBox based on the bbox member of this class
;;;;;;;;;;;;;;;;;;;;;;;;;;;;;;;;;;;;;;;;;;;;;;;;;;;;;;;;;;;;;;;;;;;;;;;;;
defmethod( setbb (( bb bbox ))
  let((bbox)
    bbox=list(getLl(bb) getUr(bb))
    setBbox(bb bbox)
    dbComputeBBox(getRef(bb))
    getRef(bb)~>bBox
  );let
);defMethod

;;;;;;;;;;;;;;;;;;;;;;;;;;;;;;;;;;;;;;;;;;;;;;;;;;;;;;;;;;;;;;;;;;;;;;;;;
; This Method Gets The Width and Height cell's boundary box
;;;;;;;;;;;;;;;;;;;;;;;;;;;;;;;;;;;;;;;;;;;;;;;;;;;;;;;;;;;;;;;;;;;;;;;;;
defmethod( getDim (( bb bbox ))
	bb->width  = caadr( bb->bbox ) - caar( bb->bbox )
	bb->height = cadadr( bb->bbox ) - cadar( bb->bbox)
	setUr(bb caadr( bb->bbox ))
	setLl(bb cadar( bb->bbox))
	list(bb->width bb->height)
);defMethod

;;;;;;;;;;;;;;;;;;;;;;;;;;;;;;;;;;;;;;;;;;;;;;;;;;;;;;;;;;;;;;;;;;;;;;;;;
; This Method Gets the Cell's Origin - defined as lower left (minx,miny)
; for a boundary box
;;;;;;;;;;;;;;;;;;;;;;;;;;;;;;;;;;;;;;;;;;;;;;;;;;;;;;;;;;;;;;;;;;;;;;;;;
defmethod( Origin (( bb bbox ))
  let((x y)
    getDim(bb)
    x=caar(bb->bbox)
    y=cadar(bb->bbox)
    bb->origin=list(x y)
  );let
);defMethod

;;;;;;;;;;;;;;;;;;;;;;;;;;;;;;;;;;;;;;;;;;;;;;;;;;;;;;;;;;;;;;;;;;;;;;;;;
; This Method Finds the center of the cell's boundary box
;;;;;;;;;;;;;;;;;;;;;;;;;;;;;;;;;;;;;;;;;;;;;;;;;;;;;;;;;;;;;;;;;;;;;;;;;
defmethod( Centroid (( bb bbox ))
  let( ( urx ury llx lly  )
    getbb(bb)
    ury = yCoord( upperRight( bb->bbox ))
    urx = xCoord( upperRight( bb->bbox ))
    llx = xCoord( lowerLeft( bb->bbox ))
    lly = yCoord( lowerLeft( bb->bbox ))
    x = (urx+llx)/2
    y = (ury+lly)/2
    bb->centroid = list(x y)
  );let
);defMethod

;;;;;;;;;;;;;;;;;;;;;;;;;;;;;;;;;;;;;;;;;;;;;;;;;;;;;;;;;;;;;;;;;;;;;;;;;
; This method converts bbox coordinates to vertices
;;;;;;;;;;;;;;;;;;;;;;;;;;;;;;;;;;;;;;;;;;;;;;;;;;;;;;;;;;;;;;;;;;;;;;;;;
defmethod( bb2vert (( bb bbox ))
  let( (ury urx llx lly vo v1 v2 v3)
    ury = yCoord( upperRight( bb->bbox ))
    urx = xCoord( upperRight( bb->bbox ))
    llx = xCoord( lowerLeft( bb->bbox ))
    lly = yCoord( lowerLeft( bb->bbox ))
    v0 = list(llx lly)
    v1 = list(urx lly)
    v2 = list(urx ury)
    v3 = list(llx ury)
    setVertices(bb list(v0 v1 v2 v3 v0))
  );let
);defmethod

;;;;;;;;;;;;;;;;;;;;;;;;;;;;;;;;;;;;;;;;;;;;;;;;;;;;;;;;;;;;;;;;;;;;;;;;;
; This Method Finds the area of the cell's boundary box in square meters
; FIXME: need to get UserUnits from the techfile to do proper
;        unit conversion
;;;;;;;;;;;;;;;;;;;;;;;;;;;;;;;;;;;;;;;;;;;;;;;;;;;;;;;;;;;;;;;;;;;;;;;;;
;defmethod( getBboxArea (( bb bbox ))
;	bb2vert(bb)
;	area(bb)*1e-12
;);defMethod

;;;;;;;;;;;;;;;;;;;;;;;;;;;;;;;;;;;;;;;;;;;;;;;;;;;;;;;;;;;;;;;;;;;;;;;;;
; This method calculates the upper right and lower left of a new bounding
; centered at a new location with widths and heights given by 0.5*deltaX
; and 0.5*deltaY
;;;;;;;;;;;;;;;;;;;;;;;;;;;;;;;;;;;;;;;;;;;;;;;;;;;;;;;;;;;;;;;;;;;;;;;;;
;defmethod( setCenter (( bb bbox ) aPoint @key (deltaX 1) (deltaY 1))
; let( (llx lly urx ury aPointX aPointY)
;      apointX = xCoord( aPoint )
;      apointY = yCoord( aPoint )
;      llx = aPointX - deltaX
;      urx = aPointX + deltaX
;      ury = sPointY + deltaY
;      list( llx:lly urx:ury )
;);defmethod

;;;;;;;;;;;;;;;;;;;;;;;;;;;;;;;;;;;;;;;;;;;;;;;;;;;;;;;;;;;;;;;;;;;;;;;;;
; This method translates the bbox about its centroid
;;;;;;;;;;;;;;;;;;;;;;;;;;;;;;;;;;;;;;;;;;;;;;;;;;;;;;;;;;;;;;;;;;;;;;;;;
;defmethod( translate (( bb bbox ) arg )
;	nil
;);defMethod

;;;;;;;;;;;;;;;;;;;;;;;;;;;;;;;;;;;;;;;;;;;;;;;;;;;;;;;;;;;;;;;;;;;;;;;;;
; This method rotates the bbox about its centroid
;;;;;;;;;;;;;;;;;;;;;;;;;;;;;;;;;;;;;;;;;;;;;;;;;;;;;;;;;;;;;;;;;;;;;;;;;
;defmethod( rotate (( bb bbox ) arg )
;	nil
;);defMethod

;;;;;;;;;;;;;;;;;;;;;;;;;;;;;;;;;;;;;;;;;;;;;;;;;;;;;;;;;;;;;;;;;;;;;;;;;
; This method scales the bbox about its centroid
;;;;;;;;;;;;;;;;;;;;;;;;;;;;;;;;;;;;;;;;;;;;;;;;;;;;;;;;;;;;;;;;;;;;;;;;;
;defmethod( scale (( bb bbox ) arg)
;	nil
;);defMethod

;;;;;;;;;;;;;;;;;;;;;;;;;;;;;;;;;;;;;;;;;;;;;;;;;;;;;;;;;;;;;;;;;;;;;;;;;
; This method returns the smallest bounding box coordinates containing
; all boxes given in a list with the class box's object - Merge!!
;;;;;;;;;;;;;;;;;;;;;;;;;;;;;;;;;;;;;;;;;;;;;;;;;;;;;;;;;;;;;;;;;;;;;;;;;
;defmethod( union (( bb bbox ) box)
; let( ( llxList llyList urxList uryList minllx minlly maxurx maxury )
;      llxList = foreach(mapcar bb->bbox box xCoord( lowerLeft( bb->bbox )))
;      llyList = foreach(mapcar bb->bbox box yCoord( lowerLeft( bb->bbox )))
;      urxList = foreach(mapcar bb->bbox box xCoord( upperRight( bb->bbox )))
;      uryList = foreach(mapcar bb->bbox box yCoord( upperRight( bb->bbox )))
;      minllx = apply( 'min llxList )
;      minlly = apply( 'min llyList )
;      minllx = apply( 'max urxList )
;;      minlly = apply( 'max uryList )
;  );let
;);defMethod

;;;;;;;;;;;;;;;;;;;;;;;;;;;;;;;;;;;;;;;;;;;;;;;;;;;;;;;;;;;;;;;;;;;;;;;;;
; This method returns the intersection of two class box's object and a
; list of bboxs
;;;;;;;;;;;;;;;;;;;;;;;;;;;;;;;;;;;;;;;;;;;;;;;;;;;;;;;;;;;;;;;;;;;;;;;;;
;defmethod( intersection (( bb bbox ) box)
;  let( (llxList llyList urxList uryList maxllx maxlly minurx minury )
;       llxList = foreach(mapcar bb->bbox box xCoord( lowerLeft( bb->bbox )))
;       llyList = foreach(mapcar bb->bbox box yCoord( lowerLeft( bb->bbox )))
;       urxList = foreach(mapcar bb->bbox box xCoord( upperRight( bb->bbox )))
;       uryList = foreach(mapcar bb->bbox box yCoord( upperRight( bb->bbox )))
;       minurx = apply( 'min urxList )
;       minury = apply( 'min uryList )
;       maxllx = apply( 'max llxList )
;       maxlly = apply( 'max llyList )
;       cond(
;		( maxllx >= minurx
;	  	  nil
;		);maxllx
;		( maxlly >= minury
;	  	  nil
;		);maxlly
;		( t
;	  	  list(maxllx:maxlly minurx:minury)
;		);t
;  	);cond
;  );let
;);defmethod

;;;;;;;;;;;;;;;;;;;;;;;;;;;;;;;;;;;;;;;;;;;;;;;;;;;;;;;;;;;;;;;;;;;;;;;;;
; This Method Shifts The contents of the targeted Cellview to the upper
; right hand plane of the coordinate system base upon the boundary box
; of the target Cellview
;;;;;;;;;;;;;;;;;;;;;;;;;;;;;;;;;;;;;;;;;;;;;;;;;;;;;;;;;;;;;;;;;;;;;;;;;
defmethod( shiftURQ (( bb bbox ))
  let( (shift dx dy name cv)
    getbb(bb)
    Origin(bb)
    unless( caar(bb->bbox) == 0 && cadar( bb->bbox) == 0
      dx = -xCoord(bb->origin)
      dy = -yCoord(bb->origin)
      shift = list( list( dx dy) "R0")
      cv = getRef(bb)
      dbReopen( cv "a")
      printf( "INFO(bbox):  Shifting Cell: %s to upper-right quadrant\n" cv~>cellName)
      printf( "             Shift is: %f by %f\n" float(caar( shift)) float(cadar( shift)))
      foreach( inst cv~>instances
        dbMoveFig( inst cv shift)
      );foreach
      foreach( shape cv~>shapes
        dbMoveFig( shape cv shift)
      );foreach
      dbSave(cv)
      dbClose(cv)
    );unless
    getbb(bb)
    list( dx dy)
  );let
);defMethod

;;;;;;;;;;;;;;;;;;;;;;;;;;;;;;;;;;;;;;;;;;;;;;;;;;;;;;;;;;;;;;;;;;;;;;;;;
; This Method Shifts the origin of the bbox
;;;;;;;;;;;;;;;;;;;;;;;;;;;;;;;;;;;;;;;;;;;;;;;;;;;;;;;;;;;;;;;;;;;;;;;;;
defmethod( shiftOrigin (( bb bbox ) shift)
  let( (bllx blly burx bury bbll bbur)
    bllx = xCoord(nth(0 bb->bbox)) + xCoord(shift)
    blly = yCoord(nth(0 bb->bbox)) + yCoord(shift)
    burx = xCoord(nth(1 bb->bbox)) + xCoord(shift)
    bury = yCoord(nth(1 bb->bbox)) + yCoord(shift)
    bbll = list(bllx blly)
    bbur = list(burx bury)
    bb->bbox = list(bbll bbur)
    bb->origin = Origin(bb)
  );let
);defMethod

;;;;;;;;;;;;;;;;;;;;;;;;;;;;;;;;;;;;;;;;;;;;;;;;;;;;;;;;;;;;;;;;;;;;;;;;;
; This Method Shifts bbox Origin by provided dx and dy values
;;;;;;;;;;;;;;;;;;;;;;;;;;;;;;;;;;;;;;;;;;;;;;;;;;;;;;;;;;;;;;;;;;;;;;;;;
;defmethod( setCentroid (( bb bbox ) arg)
;  let( ( sx sy )
;  );let
;) ; defMethod

;;;;;;;;;;;;;;;;;;;;;;;;;;;;;;;;;;;;;;;;;;;;;;;;;;;;;;;;;;;;;;;;;;;;;;;;;
; This Method Shifts cellview bbox Origin by provided dx and dy values
;;;;;;;;;;;;;;;;;;;;;;;;;;;;;;;;;;;;;;;;;;;;;;;;;;;;;;;;;;;;;;;;;;;;;;;;;
;defmethod( shiftCentroidCellView (( bb bbox ) dx dy)
;	let( ( (name bb->cellName)
;		   (lib  bb->library)
;		   shift
;		   sx
;                  sy
;		   cvRef )
;		getbBox(bb)
;		cvRef = dbOpenCellViewByType( lib name "layout" "maskLayout")
;		sx = bb->x0 + dx
;      	sy = bb->y0 + dy
;      	shift = list( list( sx sy) "R0")
;		dbReopen( cvRef "a")
;		foreach( inst cvRef~>instances dbMoveFig( inst cvRef shift))
;    	foreach( shape cvRef~>shapes   dbMoveFig( shape cvRef shift))
;      	dbSave(cvRef)
;		dbClose(cvRef)
;		getbBox(bb)
;		)
;) ; defMethod

;;;;;;;;;;;;;;;;;;;;;;;;;;;;;;;;;;;;;;;;;;;;;;;;;;;;;;;;;;;;;;;;;;;;;;;;;;;;;
;;;;;;;;;;;;;;;;;;;;;;;;;;;;;;;;;;;;;;;;;;;;;;;;;;;;;;;;;;;;;;;;;;;;;;;;;;;;;
;;;;;;;;;;;;;;;;;;;;;;;;;;;;;;;;;;;;;;;;;;;;;;;;;;;;;;;;;;;;;;;;;;;;;;;;;;;;;
