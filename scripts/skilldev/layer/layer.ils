;######################################################
;# techLayer.ils: Technology layer class. Shapes member
;#                is a container for all shapes on the
;#                target layer.
;#                FIXME: shapes are depreciated. Use
;#                       transform2 class
;######################################################
defclass( techLayer (cadObj)
	  (
		( name @reader getName @writer setName )
		( purpose @reader getPurpose @writer setPurpose )
		( shapes @reader getShapes )
	  )
);defclass

;;;;;;;;;;;;;;;;;;;;;;;;;;;;;;;;;;;;;;;;;;;;;;;;;;;;;;;;;;;;;;;;;;;;;;;;;
; Class constructor
;;;;;;;;;;;;;;;;;;;;;;;;;;;;;;;;;;;;;;;;;;;;;;;;;;;;;;;;;;;;;;;;;;;;;;;;;
defmethod( initializeInstance @after ((obj techLayer))
	   obj->name = nil
	   obj->purpose = nil
	   obj->shapes = makeInstance( 'collection )
);defmethod

;;;;;;;;;;;;;;;;;;;;;;;;;;;;;;;;;;;;;;;;;;;;;;;;;;;;;;;;;;;;;;;;;;;;;;;;;
; This method gets all the shapes on the target layer
;;;;;;;;;;;;;;;;;;;;;;;;;;;;;;;;;;;;;;;;;;;;;;;;;;;;;;;;;;;;;;;;;;;;;;;;;
defmethod( getShapesOnLayer (( lay techLayer ))
  let( (shps temp)
    shps = car(setof(lp lay->ref~>lpps lp~>layerName==lay->name))~>shapes
    foreach( sh shps
      temp = makeInstance( 'shape )
      setRef(temp sh)
      genVertices(temp)
      add(lay->shapes temp)
    );foreach
  );let
);defmethod

;;;;;;;;;;;;;;;;;;;;;;;;;;;;;;;;;;;;;;;;;;;;;;;;;;;;;;;;;;;;;;;;;;;;;;;;;
; This method deletes all shapes on the target layer
; Rendor shapes on the layer
;;;;;;;;;;;;;;;;;;;;;;;;;;;;;;;;;;;;;;;;;;;;;;;;;;;;;;;;;;;;;;;;;;;;;;;;;
defmethod( deleteShapesOnLayer (( lay techLayer ))
  foreach(shape lay->shapes
      dbDeleteObject(shape)
  )
);defmethod

;;;;;;;;;;;;;;;;;;;;;;;;;;;;;;;;;;;;;;;;;;;;;;;;;;;;;;;;;;;;;;;;;;;;;;;;;
;  Render shapes on the layer
;;;;;;;;;;;;;;;;;;;;;;;;;;;;;;;;;;;;;;;;;;;;;;;;;;;;;;;;;;;;;;;;;;;;;;;;;
defmethod( renderShapesOnLayer (( lay techLayer ))
  let((i points)
    i=0
    foreach(shp lay->shapes->list->elems
      points = makeInstance( 'points2 )
      addPoints(points shp->vertices)
      setVertexCollection(shp->transform points)
      setLayer(shp->transform lay->name)
      setPurpose(shp->transform lay->purpose)
      setRef(shp getRef(lay))
      setRef(shp->transform getRef(lay))
      render(shp->transform)
      i++
    );foreach
  );let
);defmethod

;;;;;;;;;;;;;;;;;;;;;;;;;;;;;;;;;;;;;;;;;;;;;;;;;;;;;;;;;;;;;;;;;;;;;;;;;
; This method adds a shape to a layer by reference
;;;;;;;;;;;;;;;;;;;;;;;;;;;;;;;;;;;;;;;;;;;;;;;;;;;;;;;;;;;;;;;;;;;;;;;;;
defmethod( addShape (( lay techLayer ) arg )
  if( getName(lay) == getLayer(arg) then
    printf("INFO: Adding shape to layer\n")
    add(lay->shapes arg)
    t
  else
    printf("ERROR: Shape is on %s layer, cannot be added to %s layer\n" getLayer(arg) getName(lay))
    nil
  );if
);defmethod

;;;;;;;;;;;;;;;;;;;;;;;;;;;;;;;;;;;;;;;;;;;;;;;;;;;;;;;;;;;;;;;;;;;;;;;;;
;  Performs the logical AND of the two input layer objects
;  Returns: A list of shapes that satisfy the logical AND operation
;           nil if there is no output from the AND
;;;;;;;;;;;;;;;;;;;;;;;;;;;;;;;;;;;;;;;;;;;;;;;;;;;;;;;;;;;;;;;;;;;;;;;;;
defmethod( andLayers (( lay techLayer ) other )
  let((layA purA temp)
    layA = getLayer(other)
    purA = getPurpose(other)
    layB = getLayer(lay)
    purB = getPurpose(lay)
    leLayerAnd(getRef(lay) list(layA purA) list(layB purB) list("text" "drawing"))
  );let
);defmethod

;;;;;;;;;;;;;;;;;;;;;;;;;;;;;;;;;;;;;;;;;;;;;;;;;;;;;;;;;;;;;;;;;;;;;;;;;
;  Performs the logical AND NOT of the two input layer objects
;  Returns: A list of shapes that satisfy the logical AND operation
;           nil if there is no output from the AND
;;;;;;;;;;;;;;;;;;;;;;;;;;;;;;;;;;;;;;;;;;;;;;;;;;;;;;;;;;;;;;;;;;;;;;;;;
defmethod( andNotLayers (( lay techLayer ) other )
  let((layA purA temp)
    layA = getLayer(other)
    purA = getPurpose(other)
    layB = getLayer(lay)
    purB = getPurpose(lay)
    leLayerAndNot(getRef(lay) list(layA purA) list(layB purB) list("text" "drawing"))
  );let
);defmethod

;;;;;;;;;;;;;;;;;;;;;;;;;;;;;;;;;;;;;;;;;;;;;;;;;;;;;;;;;;;;;;;;;;;;;;;;;
;  Performs the logical OR of the two input layer objects
;  Returns: A list of shapes that satisfy the logical AND operation
;           nil if there is no output from the AND
;;;;;;;;;;;;;;;;;;;;;;;;;;;;;;;;;;;;;;;;;;;;;;;;;;;;;;;;;;;;;;;;;;;;;;;;;
defmethod( orLayers (( lay techLayer ) other )
  let((layA purA temp)
    layA = getLayer(other)
    purA = getPurpose(other)
    layB = getLayer(lay)
    purB = getPurpose(lay)
    leLayerOr(getRef(lay) list(layA purA) list(layB purB) list("text" "drawing"))
  );let
);defmethod

;;;;;;;;;;;;;;;;;;;;;;;;;;;;;;;;;;;;;;;;;;;;;;;;;;;;;;;;;;;;;;;;;;;;;;;;;
;  Performs the logical XOR of the two input layer objects
;  Returns: A list of shapes that satisfy the logical AND operation
;           nil if there is no output from the AND
;;;;;;;;;;;;;;;;;;;;;;;;;;;;;;;;;;;;;;;;;;;;;;;;;;;;;;;;;;;;;;;;;;;;;;;;;
defmethod( xOrLayers (( lay techLayer ) other )
  let((layA purA temp)
    layA = getLayer(other)
    purA = getPurpose(other)
    layB = getLayer(lay)
    purB = getPurpose(lay)
    leLayerXor(getRef(lay) list(layA purA) list(layB purB) list("text" "drawing"))
  );let
);defmethod

;;;;;;;;;;;;;;;;;;;;;;;;;;;;;;;;;;;;;;;;;;;;;;;;;;;;;;;;;;;;;;;;;;;;;;;;;
;  Resizes the shapes on this layer by useru (um) and returns
;  a list of newly resized shapes on this layer
;;;;;;;;;;;;;;;;;;;;;;;;;;;;;;;;;;;;;;;;;;;;;;;;;;;;;;;;;;;;;;;;;;;;;;;;;
defmethod( resizeLayer (( lay techLayer ) uu )
  let((layA purA temp)
    lay = getLayer(other)
    pur = getPurpose(other)
    leLayerSize(getRef(lay) list(lay pur) uu list(lay pur))
  );let
);defmethod

;;;;;;;;;;;;;;;;;;;;;;;;;;;;;;;;;;;;;;;;;;;;;;;;;;;;;;;;;;;;;;;;;;;;;;;;;
;  Merge all shapes on a layer. Returnts a list of shapes that have
;  been returned from the merger operation
;;;;;;;;;;;;;;;;;;;;;;;;;;;;;;;;;;;;;;;;;;;;;;;;;;;;;;;;;;;;;;;;;;;;;;;;;
defmethod( mergeLayer (( lay techLayer ))
  let((cv sList)
    cv = getRef(lay)
    foreach(layer cv~>lpps
      if(layer~>layerName == getName(lay) && layer~>purpose == getPurpose(lay) then
        foreach(shp layer~>shapes
          sList = cons(shp sList)
        );foreach
      );if
    );foreach
    ; get the target layer from the cv
    ; get the shapes on that layer and add them to sList
    leMergeShapes(sList)
  )
);defmethod

;;;;;;;;;;;;;;;;;;;;;;;;;;;;;;;;;;;;;;;;;;;;;;;;;;;;;;;;;;;;;;;;;
;;;;;;;;;;;;;;;;;;;;;;;;;;;;;;;;;;;;;;;;;;;;;;;;;;;;;;;;;;;;;;;;;
;;;;;;;;;;;;;;;;;;;;;;;;;;;;;;;;;;;;;;;;;;;;;;;;;;;;;;;;;;;;;;;;;
