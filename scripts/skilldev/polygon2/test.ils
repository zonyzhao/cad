;;;;;;;;;;;;;;;;;;;;;;;;;;;;;;;;;;;
; UT-0: test existence and constructor
;;;;;;;;;;;;;;;;;;;;;;;;;;;;;;;;;;;
findClass( 'polygon2 )
poly = makeInstance( 'polygon2 )
classp( poly 'polygon2)
classOf(poly)
poly->vertices
getVertices(poly)

;;;;;;;;;;;;;;;;;;;;;;;;;;;;;;;;;;;
; UT-1: Add vertices list to Polygon
;       and find polygon Area
;;;;;;;;;;;;;;;;;;;;;;;;;;;;;;;;;;;
; 100x100 Square
v0 = list(0.0 0.0)
v1 = list(0.0 100.0)
v2 = list(100.0 100.0)
v3 = list(100.0 0.0)
v4 = list(0.0 0.0)
vertices = list(v0 v1 v2 v3 v4)

poly = makeInstance( 'polygon2 )
setVertices(poly vertices)
area(poly)

;;;;;;;;;;;;;;;;;;;;;;;;;;;;;;;;;;;
; UT-2: Add vertices list to Polygon
;       and find polygon Centroid
;;;;;;;;;;;;;;;;;;;;;;;;;;;;;;;;;;;
; 100x100 Square
v0 = list(0.0 0.0)
v1 = list(0.0 100.0)
v2 = list(100.0 100.0)
v3 = list(100.0 0.0)
v4 = list(0.0 0.0)
vertices = list(v0 v1 v2 v3 v4)

poly = makeInstance( 'polygon2 )
setVertices(poly vertices)
centroid(poly)

;;;;;;;;;;;;;;;;;;;;;;;;;;;;;;;;;;;
; UT-3: render the square
;;;;;;;;;;;;;;;;;;;;;;;;;;;;;;;;;;;
v0 = list(0.0 0.0)
v1 = list(0.0 100.0)
v2 = list(100.0 100.0)
v3 = list(100.0 0.0)
v4 = list(0.0 0.0)
vertices = list(v0 v1 v2 v3 v4)
poly = makeInstance( 'polygon2 )
setVertices(poly vertices)
area(poly)
centroid(poly)
lib="test"
name="squareTest"
cv = dbOpenCellViewByType( lib name "layout" "maskLayout" "w")
setRef(poly cv)
render(poly)
dbSave(cv)
dbClose(cv)

;;;;;;;;;;;;;;;;;;;;;;;;;;;;;;;;;;;
; UT-3: render a quarter circle (arc)
;;;;;;;;;;;;;;;;;;;;;;;;;;;;;;;;;;;
circle = makeInstance( 'circle )
circle->radius = 25
generateQuarterCircle(circle)
poly = makeInstance( 'polygon2 )
setVertices(poly getVertices(circle))
name="halfCircleTest"
lib = "test"
cv = dbOpenCellViewByType( lib name "layout" "maskLayout" "w")
setRef(poly cv)
render(poly)
dbSave(cv)
dbClose(cv)

;;;;;;;;;;;;;;;;;;;;;;;;;;;;;;;;;;;
; UT-4: Testing rotation on
;       quarter circle (arc)
;;;;;;;;;;;;;;;;;;;;;;;;;;;;;;;;;;;
circle = makeInstance( 'circle )
circle->radius = 25
generateQuarterCircle(circle)
poly = makeInstance( 'polygon2 )
setVertices(poly getVertices(circle))
rotate(poly 90.0)
name="halfCircleRotTest"
lib = "test"
cv = dbOpenCellViewByType( lib name "layout" "maskLayout" "w")
setRef(poly cv)
render(poly)
dbSave(cv)
dbClose(cv)

;;;;;;;;;;;;;;;;;;;;;;;;;;;;;;;;;;;
; UT-5: Testing scaling on
;       quarter circle (arc)
;;;;;;;;;;;;;;;;;;;;;;;;;;;;;;;;;;;
circle = makeInstance( 'circle )
circle->radius = 25
generateQuarterCircle(circle)
poly = makeInstance( 'polygon2 )
setVertices(poly getVertices(circle))
scale(poly 2.0)
name="quarterCircleScaleTest"
lib = "test"
cv = dbOpenCellViewByType( lib name "layout" "maskLayout" "w")
setRef(poly cv)
render(poly)
dbSave(cv)
dbClose(cv)

;;;;;;;;;;;;;;;;;;;;;;;;;;;;;;;;;;;
; UT-4: Testing rotation on
;       half circle (arc)
;;;;;;;;;;;;;;;;;;;;;;;;;;;;;;;;;;;
circle = makeInstance( 'circle )
circle->radius = 25
generateHalfCircle(circle)
;
center(circle)
;
poly = makeInstance( 'polygon2 )
setVertices(poly getVertices(circle))
rotate(poly 90.0)
name="halfCircleRotTestPoly"
lib = "test"
cv = dbOpenCellViewByType( lib name "layout" "maskLayout" "w")
setRef(poly cv)
render(poly)
dbSave(cv)
dbClose(cv)

;;;;;;;;;;;;;;;;;;;;;;;;;;;;;;;;;;;
; UT-5: Testing rotation on
;       half circle (arc)
;;;;;;;;;;;;;;;;;;;;;;;;;;;;;;;;;;;
tri = makeInstance( 'triangle )
setBase(tri 10.0)
setHeight(tri 10.0)
generate(tri)
;
center(tri)
;
poly = makeInstance( 'polygon2 )
setVertices(poly getVertices(tri))
rotate(poly 180.0)
name="triRotTestPoly"
lib = "test"
cv = dbOpenCellViewByType( lib name "layout" "maskLayout" "w")
setRef(poly cv)
render(poly)
dbSave(cv)
dbClose(cv)

;;;;;;;;;;;;;;;;;;;;;;;;;;;;;;;;;;;
; UT-6: render a circle and test
;       its rectTran
;;;;;;;;;;;;;;;;;;;;;;;;;;;;;;;;;;;
circle = makeInstance( 'circle )
circle->radius = 25
generate(circle)
poly = makeInstance( 'polygon2 )
setVertices(poly getVertices(circle))
setRectTran(poly)
getUpperRight(poly->rtran)
getLowerLeft(poly->rtran)
getCentroid(poly->rtran)
isCentered(poly->rtran)
name="CircleRtranTest"
lib = "test"
cv = dbOpenCellViewByType( lib name "layout" "maskLayout" "w")
setRef(poly cv)
render(poly)
setRef(poly->rtran cv)
render(poly->rtran)
dbSave(cv)
dbClose(cv)

;;;;;;;;;;;;;;;;;;;;;;;;;;;;;;;;;;;
; UT-7: render a circle and test
;       its rectTran
;;;;;;;;;;;;;;;;;;;;;;;;;;;;;;;;;;;

;;;;;;;;;;;;;;;;;;;;;;;;;;;;;;;;;;;
; UT-8: Test if point is inside
;       a polygon - rectangle
;;;;;;;;;;;;;;;;;;;;;;;;;;;;;;;;;;;
v0 = list(0.0 0.0)
v1 = list(0.0 100.0)
v2 = list(100.0 100.0)
v3 = list(100.0 0.0)
v4 = list(0.0 0.0)
vertices = list(v0 v1 v2 v3 v4)
poly = makeInstance( 'polygon2 )
setVertices(poly vertices)
area(poly)
centroid(poly)
;translate(poly list(-50.0 -50.0))
;area(poly)
;centroid(poly)
;Positives
point = list(20.0 20.0)
point = list(0.0 0.0)
point = list(99.0 99.0)
isPointInside(poly point)
;Negatives
point = list(60.0 -60.0)
point = list(55.0 50.0)
;;;;;;;;;;;;;;;;;;;;;;;;;;
; Special Cases
; on a vertex
point = list(100.0 100.0)
; On a vertex
point = list(0.0 0.0)
; On an edge
point = list(50.0 0.0)
; On an edge
point = list(0.0 50.0)
; "Creeping up" on a vertex
; checking the boundary conditions
; decimal.binary
point = list(99.0 99.0)
point = list(99.5 99.5)
point = list(99.75 99.75)
point = list(99.875 99.875)
point = list(99.9375 99.9375)
point = list(99.96875 99.96875)
point = list(99.99999 99.99999)
point = list(99.99999 100.0000)
point = list(100.00000  99.99999)
point = list(100.00000 100.00000)
point = list(100.00001 100.00000)
point = list(100.00000 100.00001)
point = list(100.00001 100.00001)
point = list(100.00000 100.09375)
point = list(100.09375 100.00000)
point = list(100.09375 100.09375)
point = list(100.0625 100.0000)
isPointInside(poly point)

;;;;;;;;;;;;;;;;;;;;;;;;;;;;;;;;;;;
; UT-9: Test if point is inside
;       a polygon - circle
; WIP: Debug Mode
;;;;;;;;;;;;;;;;;;;;;;;;;;;;;;;;;;;
circle = makeInstance( 'circle )
circle->radius = 5
generate(circle)
poly = makeInstance( 'polygon2 )
setVertices(poly getVertices(circle))
; positives
point = list(0.0 0.0)
point = list(2.0 2.0)
point = list(-2.0 2.0)
point = list(-2.0 -2.0)
point = list(2.0 -2.0)
point = list(5.0 0.0)
point = list(4.0 0.0)
; negatives
point = list(10.0 10.0)
point = list(20.0 20.0)
point = list(-20.0 20.0)
point = list(-20.0 -20.0)
point = list(20.0 -20.0)
isPointInside(poly point)
area(poly)
centroid(poly)
;translate(poly list(5 5))
centroid(poly)
area(poly)

;;;;;;;;;;;;;;;;;;;;;;;;;;;;;;;;;;;
; FIXME: move to transform class
; UT-?: Test all vertices of a
;       a polygon are on grid
;;;;;;;;;;;;;;;;;;;;;;;;;;;;;;;;;;;
circle = makeInstance( 'circle )
circle->radius = 5
generate(circle)
poly = makeInstance( 'polygon2 )
setVertices(poly getVertices(circle))
isPolyOnGrid(poly)
setPolyOnGrid(poly)
isPolyOnGrid(poly)
point = list(1.0 1.0)
isPointInside(poly point)

;;;;;;;;;;;;;;;;;;;;;;;;;;;;;;;;;;;
; Experimental Code
;;;;;;;;;;;;;;;;;;;;;;;;;;;;;;;;;;;
i=0
j=1
term0 = xCoord(nth(i vertices))*yCoord(nth(j vertices))
term1 = xCoord(nth(j vertices))*yCoord(nth(i vertices))
;;;;;;;;;;;;;;;;;;;;;;;;;;;;;;;;;;;
area = 0.0
len = length(vertices)
i=0
for( i 0 length(vertices)-1
	j = modulo(i+1 len)
	term0 = xCoord(nth(i vertices))*yCoord(nth(j vertices))
	term1 = xCoord(nth(j vertices))*yCoord(nth(i vertices))
	area = area + (term0 - term1)
	i = i+1
);for

if( area < 0 then
    area = -1*area
)
area = 0.5*area
