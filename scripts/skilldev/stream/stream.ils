;;;;;;;;;;;;;;;;;;;;;;;;;;;;;;;;;;;;;;;;;;;;;;;;;;;;;;;;;;;;;;;;;;;;;;;;;;;;;;;;
;;;;;;;;;;;;;;;;  stream.ils: cellview stream class
;;;;;;;;;;;;;;;;;;;;;;;;;;;;;;;;;;;;;;;;;;;;;;;;;;;;;;;;;;;;;;;;;;;;;;;;;;;;;;;;
defclass( stream (cv)
  (
    ( strmFile @reader getStrmFile @writer setStrmFile )
    ( runDir @reader getRunDir @writer setRunDir )
    ( logFile @reader getLogFile @writer setLogFile )
    ( errFile @reader getErrFile @writer setErrFile )
    ( maxVertices @reader getMaxVertices @writer setMaxVertices )
    ( mapFile @reader getMapFile @writer setMapFile )
    ( mapPath @reader getMapPath @writer setMapPath )
    ( templatePath @reader getTemplatePath @writer setTemplatePath )
    ( templateFile @reader getTemplateFile @writer setTemplateFile )
  )
);defClass
;#####################################################
; Constructor Method
;#####################################################
defmethod( initializeInstance @after ((obj stream))
  obj->strmFile = nil
  obj->runDir = "."
  obj->logFile = "strmOut.log"
  obj->errFile = "strmOut.err"
  obj->maxVertices = "200"
  obj->mapFile = "layer.map"
  obj->mapPath = "."
  obj->templatePath = "."
  obj->templateFile = nil
);defmethod
;######################################################
;#####################################################
; Sets the boundary box of the chip numbers pad
;################################################f#####
defmethod(streamOut  (( str stream ))
  let((streamOutKeys tFile fp id)
    if(null(str->templateFile) then
      ; create a dpl for the default stream out template file
      streamOutKeys=ncons(nil)
      streamOutKeys->topCell=str->name
      streamOutKeys->library=str->lib
      streamOutKeys->view=str->view
      streamOutKeys->logFile=str->logFile
      streamOutKeys->errFile=str->errFile
      streamOutKeys->maxVertices="200"
      streamOutKeys->layerMap=strcat(str->mapPath "/" str->mapFile)
      streamOutKeys->labelCase="preserve"
      streamOutKeys->case="preserve"
      streamOutKeys->labelDepth="1"
      streamOutKeys->subMasterSeparator="_CDNS_"
      streamOutKeys->strmVersion="5"
;      streamOutKeys->strmFile=str->strmFile
;      streamOutKeys->runDir=str->runDir
      str->templatePath = str->runDir
      ; Create a default template file
      tFile=strcat(str->runDir "/.streamOutKeys")
      fp=outfile(tFile)
      fprintf(fp "streamOutKeys='")
      pprint(streamOutKeys fp)
      newline(fp)
      close(fp)
    else
      tFile = strcat(str->templatePath "/" str->templateFile)
    );if
    id=ipcBeginProcess(
      sprintf(nil "strmout -templateFile %s" tFile)
      ""
      'strmDataHandler
      'strmDataHandler
      'strmExitHandler
      "./ipcAsync.log"
    );ipcBeginProcess
    ; use ipcWait(id) if you want to wait for it to finish
  );let
);defmethod
;#####################################################
; FIXME: Should integrate this with the IPC class and
;        use this as a test case ... CONFIRMED!!
;#####################################################
; IPC Data Handler
;#####################################################
defun(strmDataHandler (_id data)
  printf("%s" data)
);defun
;#####################################################
; IPC Exit Handler Callback
;#####################################################
defun(strmExitHandler (_id status)
  printf("Stream Out exited with status %L\n" status)
);defun
;######################################################
;#####################################################
; Get the target template path and file
;#####################################################
defmethod(getTemplateTarget  (( str stream ))
  printf("INFO(stream): Target Template File:  %s\n" strcat(str->templatePath str->templateFile))
);defmethod
;######################################################
;######################################################
;######################################################
