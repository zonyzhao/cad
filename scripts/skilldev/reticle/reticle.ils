;;;;;;;;;;;;;;;;;;;;;;;;;;;;;;;;;;;;;;;;;;;;;;;;;;;;;;;;;;;;;;;;;;;;;;;;;;;;;;;;
;  reticle.il: Reticle Object
;   FIXME: After the inner streets are checked for compliance, there needs to be
;          a check to ensure that the outter streets of the combined die site
;          outter streets are centered within the reticle outline. The combination
;          of these checks ensures that the inter and intra reticle streets are
;          periodic and can be numbered via the commutative numbering algorithm
;  FIXME: Coupon XYNPADS need to be detected within the overhead block
;;;;;;;;;;;;;;;;;;;;;;;;;;;;;;;;;;;;;;;;;;;;;;;;;;;;;;;;;;;;;;;;;;;;;;;;;;;;;;;;
defclass( reticle (cv)
	  (
		( srRes @reader getRes @writer setRes)
		( srGrid @reader getSrGrid @writer setSrGrid)
		( overlap @reader getOverlap @writer setOverlap)
		( maxDim @reader getMaxDim @writer setMaxDim)
		( xynPadChipName @reader getPadChipName @writer setPadChipName)
		( xynPadOverheadName @reader getPadOverheadName @writer setPadOverheadName)
		( xynPadCouponName @reader getPadCouponName @writer setPadCouponName)
		( validDim @reader getDimValid)
		( validRes @reader getResValid)
		( shiftUrq @reader getShiftUrq @writer setShiftUrq)
		( frame @reader getFrame)
		( frameName @reader getFrameName  @writer setFrameName)
		( chipList @reader getChipList)
		( olist @reader getOverheadList)
		( couponList @reader getCouponList)
		( dieSites @reader getDieSites )
		( die )
		( chips @reader getChips)
		( overhead @reader getOverhead)
		( coupons @reader getCoupons)
		( isPartial @reader getIsPartial )
		( numRetChips @reader getNumRetChips @writer setNumRetChips)
		( numRetOverhead @reader getNumRetOverhead @writer setNumRetOverhead)
		( numRetCoups @reader getNumRetCoups @writer setNumRetCoups)
		( numNumPads @reader getNumNumPads)
		( innerStreetOrigs @reader getInnerStreetOrigs)
		( bnb @reader getBnb)
		( dieSiteOrig @reader getDieSiteOrig)
		( dieSiteArray @reader getDieSiteArray)
		( waferRow @reader getWaferRow @writer setWaferRow)
		( waferCol @reader getWaferCol @writer setWaferCol)
	  )
);defClass
;#####################################################
; Constructor Method
;#####################################################
defmethod( initializeInstance @after ((obj reticle))
	   obj->srRes = nil
	   obj->srGrid = nil
	   obj->overlap = nil
	   obj->maxDim = nil
	   obj->xynPadChipName = nil
	   obj->xynPadOverheadName = nil
	   obj->xynPadCouponName = nil
	   obj->validDim = nil
	   obj->validRes = nil
	   obj->shiftUrq = nil
	   obj->frame = makeInstance( 'reticleFrame )
	   obj->frameName = "memsChipFrame"
 	   obj->die = nil
	   obj->dieSites = makeInstance( 'collection )
	   obj->chipList = nil
	   obj->olist = nil
	   obj->couponList = nil
	   obj->chips = makeInstance( 'collection )
	   obj->overhead = makeInstance( 'collection )
	   obj->coupons = makeInstance( 'collection )
	   obj->isPartial = nil
	   obj->origin = nil
	   obj->numRetChips = nil
	   obj->numRetOverhead = nil
	   obj->numRetCoups = nil
	   obj->numNumPads = nil
	   obj->bnb = makeInstance( 'collection )
	   obj->dieSiteOrig = nil
	   obj->dieSiteArray = nil
	   obj->waferRow = nil
	   obj->waferCol = nil
);defmethod
;######################################################
; Clones the contents of this reticle into arg reticle
;######################################################
defmethod( cloneRet ((ret reticle) arg)
   arg->srRes              = ret->srRes
   arg->srGrid 	           = ret->srGrid
   arg->overlap	           = ret->overlap
   arg->maxDim 	           = ret->maxDim
   arg->xynPadChipName 	   = ret->xynPadChipName
   arg->xynPadOverheadName = ret->xynPadOverheadName
   arg->xynPadCouponName   = ret->xynPadCouponName
   arg->validDim	   = ret->validDim
   arg->validRes           = ret->validRes
   arg->shiftUrq           = ret->shiftUrq
   arg->frame	           = ret->frame
   arg->frameName          = ret->frameName
   arg->chipList	   = ret->chipList
   arg->olist 	           = ret->olist
   arg->couponList 	   = ret->couponList
   arg->die                = ret->die
   arg->chips 	           = ret->chips
   arg->overhead 	   = ret->overhead
   arg->coupons	           = ret->coupons
   arg->isPartial	   = ret->isPartial
   arg->origin	           = ret->origin
   arg->numRetChips 	   = ret->numRetChips
   arg->numRetOverhead	   = ret->numRetOverhead
   arg->numRetCoups	   = ret->numRetCoups
   arg->numNumPads 	   = ret->numNumPads
   arg->bnb	           = ret->bnb
   arg->dieSiteOrig        = ret->dieSiteOrig
   arg->dieSiteArray       = ret->dieSiteArray
   arg->waferRow           = ret->waferRow
   arg->waferCol           = ret->waferCol
   cloneDieSites(ret arg)
   cloneCv(ret arg)
);defmethod

;######################################################
; Clones the die site collection
;######################################################
defmethod( cloneDieSites ((ret reticle) arg)
  let((col die)
    col = makeInstance( 'collection )
    foreach(item getCollection(ret->dieSites)
      die = makeInstance( 'die )
      cloneDie(item die)
      add(col die)
    );foreach
    arg->dieSites = col
  );let
);defmethod

;######################################################
; This method checks to make sure reticle width and
; height do not exceed the maximum dimension (maxDim)
;######################################################
defmethod( checkDim ((ret reticle))
  ret->validDim = 't
  getbb(ret)
  getDim(ret)
  if(getWidth(ret) > getMaxDim(ret) then
    printf("ERROR: Reticle Width %8.1f exceeds maximum dimension %f\n" float(getWidth(ret)) float(ret->maxDim) )
    ret->validDim = nil
  else
    printf("INFO: Reticle Width %8.1f is less than maximum dimension %f\n" float(getWidth(ret)) float(ret->maxDim) )
  );if
  if(getHeight(ret) > getMaxDim(ret) then
    printf("ERROR: Reticle Length %8.1f exceeds maximum dimension %f\n" float(getHeight(ret)) float(ret->maxDim) )
    ret->validDim = nil
  else
    printf("INFO: Reticle Length %8.1f is less than maximum dimension %f\n" float(getHeight(ret)) float(ret->maxDim) )
  );if
);defmethod

;#####################################################
; This method checks the reticle's bbox dimensions
; (width and height) for grid requirements????
; FIXME: Get grid information from TF via grid class
;#####################################################
defmethod( checkGrid ((ret reticle))
  getbb(ret)
  getDim(ret)
  if( abs(quotient(getWidth(ret) ret->srGrid 1.0) - round(getWidth(ret)*10)) > 0.0 then
    printf("ERROR: Reticle Width %g NOT ON a %g um grid\n" float(getWidth(ret)) float(ret->srGrid))
  else
    printf("INFO: Reticle Width %g step is CORRECTLY on a %g um grid\n" float(getWidth(ret)) float(ret->srGrid))
  );if
  if( abs(quotient(getHeight(ret) ret->srGrid 1.0) - round(getHeight(ret)*10)) > 0.0 then
    printf("ERROR: Reticle Height %g step resolution NOT ON a %g um grid\n" ret->bb->height ret->srGrid)
  else
    printf("INFO: Reticle Height %g step is CORRECTLY on a %g um grid\n" float(getHeight(ret)) float(ret->srGrid))
  );if
);defmethod

;#####################################################
; This method checks the reticle's bbox dimensions
; (width and height) for Step and Repeat (S&R) value
; provided
;#####################################################
defmethod( checkRes (( ret reticle ))
 let((rwidth rheight)
    ret->validRes = 't
    getbb(ret)
    getDim(ret)
    rwidth =  getWidth(ret) - ret->overlap
    rheight = getHeight(ret) - ret->overlap
    printf("INFO: Reticle Overlap Setting: %5.1f\n" float(ret->overlap))
    printf("INFO: Reticle S&R Setting: %5.1f\n" float(ret->srRes))
    if(quotient(rwidth ret->srRes) - int(quotient(rwidth ret->srRes)) > 0 then
      printf("ERROR: Overlap Compensated Reticle Width %5.1f DOES NOT MEET required S&R step resolution of %3.1f\n" float(rwidth) float(ret->srRes))
      ret->validRes = nil
    else
      printf("INFO: Overlap Compensated Reticle Width %5.1f MEETS required S&R step resolution of %3.1f\n" float(rwidth) float(ret->srRes))
    );if
    if(quotient(rwidth ret->srRes) - int(quotient(rwidth ret->srRes)) > 0 then
      printf("ERROR: Overlap Compensated Reticle Length %5.1f DOES NOT MEET required S&R step resolution of %3.1f\n" float(rheight) float(ret->srRes))
      ret->validRes = nil
    else
      printf("INFO: Overlap Compensated Reticle Length %5.1f MEETS required S&R step resolution of %3.1f\n" float(rheight) float(ret->srRes))
    );if
  );let
); defmethod

;#####################################################
; This method checks the periodicity of the inside
; streets of reticle and ensures that each inner street
; extends the full length of the reticle without any
; jogging
;
; 1.) generate a row/col matrix for the die sites
; 2.) find the origin of all die sites
; 3.) make sure the row,col matrix origin coordinates
;     are periodic in their respective dimension
;#####################################################
;defmethod( CheckPeriodicity (( ret reticle ))
  ; Periodicity check of verticle streets
  ;;;;;;;;;;;;;;;;;;;;;;;;;;;;;;;;;;;;;;;;;;;;;
  ; Scribe line pointer
  ; xs = 0
  ; xs = getVerticalScribes(ret)
  ;
  ; Intra-Reticle (Die Site Counter)
  ; lx = 0
  ; while( car( inst~>xy) - lx > xynpl->retW
  ;	ix = ix + length( sl)
  ;	lx = lx + xynpl->retW
  ;    )
  ;     advance to the next scribe line,
  ;     or reset to the first scribe when we pass the right edge of reticle:
  ;    xs = or( cdr( xs) sl)
  ;x = xCoord(getOrigin(ret))
  ;while( x >= getWidth(ret)
  ;       printf("X coordinate %L is greater than reticle width %L subtracting width" x getWidth(ret))
  ;       x = x - getWidth(ret)
  ;       printf( "New X value %L:" x )
  ;);while
  ;
;  nil
;);

;#####################################################
; Checks that inner streets are conformant to the
; requirement that they extend the full length of
; the reticle
;#####################################################
defmethod( checkInnerStreets (( ret reticle ))
  let( ( slx sly sorted cols rows origsx origsy dieCount dieSiteCount slxc slyc dsc dscList n conform)
    origsx = '()
    origsy = '()
    foreach( dieSite getCollection(ret->dieSites)
      origsx = cons(xCoord(Origin(dieSite)) origsx)
      origsy = cons(yCoord(Origin(dieSite)) origsy)
    );foreach
    slx = '()
    foreach( posx origsx
       if(null(member(posx slx)) then
         slx = cons(posx slx)
       );if
    );foreach
    sly = '()
    foreach( posy origsy
       if(null(member(posy sly)) then
         sly = cons(posy sly)
       );if
    );foreach
    foreach( posx origsx
      ;printf( "Die Site X Position: %L\n" posx)
      ; create a list of chip unique x values
      ; INLINE IF: if(member( car( posn) sl)  sl = cons( car( posn)  sl):nil)
      unless( member( car( origsx) slx) slx = cons( car( origsx) slx))
      cdr(origsx)
    );foreach
    foreach( posy origsx
      ;printf( "Die Site Y Position: %L\n" posy)
      ; create a list of chip unique y values
      ; INLINE IF: if(member( car( posn) sl)  sl = cons( car( posn)  sl):nil)
      unless( member( car( origsy) sly) sly = cons( car( origsx) sly))
      cdr(origsy)
    );foreach
    sortedx = sort( slx 'lessp)
    sortedy = sort( sly 'lessp)
    printf("INFO: Number of Vertical Inner Streets Detected: %d\n" length(sortedx))
    printf("INFO: Number of Horizontal Inner Streets Detected: %d\n" length(sortedy))
    dieSiteCount = length(sortedx)*length(sortedy)
    dieCount = length(getCollection(ret->dieSites))
    if(dieSiteCount != dieCount then
       printf("ERROR: Die number: %d, NOT EQUAL TO Die site inner street defined array total: %d\n"  dieCount dieSiteCount)
       println("ERROR: Non-Conformant Inner Street Structure!")
       conform = nil
    else
       printf("INFO: Die number: %d, EQUALS Die site inner street defined array total: %d\n"  dieCount dieSiteCount)
       println("INFO: Conformant Inner Street Structure")
       conform = 't
    );
    if(conform then
      println( "Reticle Vertical Scribe Line X Coord List:")
      cols=0
      slxc = '()
      foreach(sort sortedx
        printf( "%d.) SLX Coord: %L\n" cols sort)
        slxc = cons(sort slxc)
        cols++
      );foreach
      println( "Reticle Horizontal Scribe Line Y Coord List:")
      rows=0
      slyc = '()
      foreach(sort sortedy
        printf( "%d.) SLY Coord: %L\n" rows sort)
        slyc = cons(sort slyc)
        rows++
      );foreach
      ;println( "Reticle Street Array Defined Die Site Origin List:")
      n = 0
      dscList = '()
      for(i 0 sub1(rows)
        for(j 0 sub1(cols)
          dsc = list(nth(i slxc) nth(j slyc))
      	  dscList = cons(dsc dscList)
          ;printf("%d.) ROW: %d COL: %d, Origin: %L\n" n i j dsc)
	  n++
        );for
      );for
      ret->dieSiteOrig = dscList
      ret->dieSiteArray = list(cols rows)
    else
      nil
    );if
  );let
);defmethod

;#####################################################
; Generates the intra reticle die sites. Need to run
; "checkInnerStreets" method first.
; FIXME: need checksum validation. Make sure that the number
;        of generated die sites equals the number of
;        die in the reticle and that the origins of
;        the generated die site and the actual die
;        origins are also equivalent.
;#####################################################
defmethod( arrayDieSites (( ret reticle ))
  let((n dorig ind aorig)
    foreach( die getCollection(ret->dieSites)
      dorig = Origin(die)
      ind = 0
      for(i 0 sub1(xCoord(ret->dieSiteArray))
        for(j 0 sub1(yCoord(ret->dieSiteArray))
          ind = i*xCoord(ret->dieSiteArray) + j
          aorig = nth(ind ret->dieSiteOrig)
	  if(xCoord(dorig) == xCoord(aorig) && yCoord(dorig) == yCoord(aorig) then
	    setReticleRow(die i)
	    setReticleCol(die j)
          );if
        );for
      );for
    );foreach
    n = 0
    foreach( die getCollection(ret->dieSites)
      printf("INFO: die #%d, ROW: %d COL: %d\n" n getReticleRow(die) getReticleCol(die))
      n++
    )
   n
  );let
);defmethod

;#####################################################
; This method checks the reticle's bbox dimensions
; (width and height) for Step and Repeat (S&R) value
; provided
;#####################################################
defmethod( chipId (( ret reticle ))
  nil
);

;#####################################################
; This method checks the reticle's bbox dimensions
; (width and height) for Step and Repeat (S&R) value
; provided
;#####################################################
defmethod( renderRetBbox (( ret reticle ))
  let((bbv shp lay dsbbv dshp)
    bbv = bb2vert(ret)
    shp = makeInstance( 'shape )
    setLayer(shp "GRID")
    setPurpose(shp "drawing")
    setVertices(shp bbv)
    setVertices(shp->transform bbv)
    lay = makeInstance( 'techLayer )
    setName(lay "GRID")
    setPurpose(lay "drawing")
    addShape(lay shp)
    foreach(ds getCollection(ret->dieSites)
      dshp = makeInstance( 'shape )
      dsbbv = bb2vert(ds)
      setLayer(dshp "GRID")
      setPurpose(dshp "drawing")
      setVertices(dshp dsbbv)
      setVertices(dshp->transform bbv)
      addShape(lay dshp)
    );foreach
    setRef(lay getRef(ret))
    renderShapesOnLayer(lay)
  );let
);
;#####################################################
; Delete reticle bbox shapes
;#####################################################
defmethod( erase (( ret reticle ))
  let((cv)
    cv = getRef(ret)
    if(!null(cv~>shapes) then
      foreach( shape cv~>shapes
        if(shape~>layerName == "GRID" then
          dbDeleteObject(shape)
        );if
      );foreach
    );if
  );let
);

;#####################################################
; This method searches the reticle instances for the
; xynPad. It only searches for the pad in instances
; one level below the top level reticle cellview
;#####################################################
defmethod( findXynPads (( ret reticle ))
  let((dlist olist clist cv numPadCount chipPadCount overheadPadCount couponPadCount chip coupon cvchip)
    resetCollection(ret->chips)
    resetCollection(ret->coupons)
    numPadCount = 0
    chipPadCount = 0
    overheadPadCount = 0
    couponPadCount = 0
    dlist = '()
    clist = '()
    cv = getRef(ret)
    foreach( ih cv~>instHeaders
      printf("Instance Header Name: %s \n" ih~>cellName)
      foreach( inst ih~>instances
        printf("Instance Name: %s \n" inst~>cellName)
        foreach( cell inst~>master~>instances
          printf("Cell Name: %s \n" cell~>cellName)
          if(!null(strcmp(cell~>cellName ret->xynPadChipName) == 0) then
	    numPadCount++
	    chipPadCount++
            printf("%d.) XYN CHIP PAD FOUND!: %s, In chip: %s \n" numPadCount cell~>cellName inst~>cellName)
	    dlist = cons(inst~>cellName dlist)
	    chip = makeInstance( 'chip )
	    setName(chip inst~>cellName)
	    setLib(chip getLib(ret))
	    setView(chip getView(ret))
	    setOrient(chip inst~>orient)
	    setBbx(getBbx(chip) inst~>bBox)
	    getDim(getBbx(chip))
	    Origin(getBbx(chip))
	    setName(chip->numpad cell~>cellName)
            setOrient(chip->numpad cell~>orient)
	    setBbx(getBbx(chip->numpad) cell~>bBox)
	    getDim(getBbx(chip->numpad))
	    Origin(getBbx(chip->numpad))
	    ;setChipBbox(chip inst~>bbox)
	    ;setPadBbox(chip cell~>bBox)
	    ;setInstanceBbox(chip inst~>bBox)
	    ;getDim(chip)
	    addChip(ret chip)
          );
	  if(!null(strcmp(cell~>cellName ret->xynPadOverheadName) == 0) then
	    numPadCount++
	    overheadPadCount++
            printf("%d.) XYN OVERHEAD PAD FOUND!: %s, In chip: %s \n" numPadCount cell~>cellName inst~>cellName)
	    olist = cons(inst~>cellName olist)
	    oh = makeInstance( 'overhead )
	    setName(oh inst~>cellName)
	    setLib(oh getLib(ret))
	    setView(oh getView(ret))
	    setOrient(oh inst~>orient)
	    setBbx(getBbx(oh) inst~>bBox)
	    getDim(getBbx(oh))
	    Origin(getBbx(oh))
	    setName(oh->numpad cell~>cellName)
            setOrient(oh->numpad cell~>orient)
	    setBbx(getBbx(oh->numpad) cell~>bBox)
	    getDim(getBbx(oh->numpad))
	    Origin(getBbx(oh->numpad))
	    ;setChipBbox(oh inst~>bbox)
	    ;setPadBbox(oh cell~>bBox)
	    ;setInstanceBbox(oh inst~>bBox)
	    ;getDim(oh)
	    addOverhead(ret oh)
          );
	  ;if(!null(strcmp(cell~>cellName ret->xynPadCouponName) == 0) then
          ;  numPadCount++
	  ;  couponPadCount++
          ;  printf("%d.) XYN COUPON PAD FOUND!: %s, In coupon: %s \n" numPadCount cell~>cellName inst~>cellName)
	  ;  clist = cons(inst~>cellName clist)
          ;);
        );foreach
      );foreach
    );foreach
    dlist = sort(dlist nil)
    clist = sort(clist nil)
    ret->chipList = dlist
    ret->olist = olist
    ret->couponList = clist
    ret->numNumPads = numPadCount
  );let
);defmethod

;;;;;;;;;;;;;;;;;;;;;;;;;;;;;;;;;;;;;;;;;;;;;;;;;;;;;;;;;;;;;;;;;;;;;;;;;;;;;;;;;
; Description: Sorts chips based on the whether the chip is a chip or a coupon,
;              then on the naming convention adopted on 06/08
;                    Chips/Legacy Coupons: NN[N]  (e.g.  99, 970)
;                    New Standard Coupons: PPNNR  (e.g. 8099A)
;                New Experimental Coupons: XPPNNR (e.g. X8001A)
;                         Legend -  N - Number
;                                   P - Process
;                                   R - Revision
;                                  [] - Optional
;;;;;;;;;;;;;;;;;;;;;;;;;;;;;;;;;;;;;;;;;;;;;;;;;;;;;;;;;;;;;;;;;;;;;;;;;;;;;;;;;

;#####################################################
; Digitizes a number (num) to a list of digits of
; length digits
;#####################################################
defmethod( digitize (( ret reticle ) num)
  let((digits format dlist)
    ;FIXME: add a second argument for digits
    digits = 3
    format = sprintf( nil "%%0%dd" digits)
    dlist = parseString( sprintf( nil format num) "")
  );let
);defmethod

;#####################################################
; Add chip to chips collection
;#####################################################
defmethod( addChip (( ret reticle ) arg)
  if( classp( arg 'chip) then
    add(ret->chips arg)
  else
    println("ERROR(reticle): Argument must be a chip object")
  );if
);defmethod

;#####################################################
; Add overhead to overhead collection
;#####################################################
defmethod( addOverhead (( ret reticle ) arg)
  if( classp( arg 'overhead) then
    add(ret->overhead arg)
  else
    println("ERROR(reticle): Argument must be an overhead object")
  );if
);defmethod

;#####################################################
; Add coupon to couponss collection
;#####################################################
defmethod( addCoupon (( ret reticle ) arg)
  if( classp( arg 'coupon) then
    add(ret->coupons arg)
  else
    println("ERROR(reticle): Argument must be a coupon object")
  );if
);defmethod

;#####################################################
; Updates the relative position, relPos member,  of the
; chips and pad locations within the reticle based upon
; the reticleOrigin value
;#####################################################
defmethod( update (( ret reticle ))
  nil
);defmethod

;#####################################################
; Updates the relative position, relPos member,  of the
; chips and pad locations within the reticle based upon
; the reticleOrigin value
;#####################################################
defmethod( checkSum (( ret reticle ))
  let((psum)
    psum = getNumRetChips(ret) + getNumRetOverhead(ret)
    if(!null(psum == getNumNumPads(ret)) then
       printf("INFO: Reticle Coupon Checksum Passed, Chips+Overhead: %d, numPads: %d\n" psum getNumNumPads(ret))
    else
       printf("ERROR: Reticle Coupon Checksum FAILED!, Chips+Overhead: %d, numPads: %d\n" psum getNumNumPads(ret))
    );
  );
);defmethod

;#####################################################
; Updates the relative position, relPos member,  of the
; chips and pad locations within the reticle based upon
; the reticleOrigin value
;#####################################################
defmethod( detectDieSites (( ret reticle ))
  let((die i cv masters instances)
    cv = getRef(ret)
    masters = cv~>instanceMasters
    instances = cv~>instances
    i = 0
    foreach( instance instances
      if(instance~>cellName == ret->frameName then
        die = makeInstance( 'die )
        setName(die instance~>cellName)
        setLib(die instance->libName)
	setBbox(die instance~>bBox)
	Origin(die)
        add(ret->dieSites die)
	printf("INFO(reticle): Die Site #%d Detected: %s\n" i  getName(die))
        printf("               ORIGIN: %L, WIDTH: %L HEIGHT: %L\n" Origin(die) getWidth(die) getHeight(die))
	i++
      );if
    );foreach
  );let
);defmethod

;#####################################################
; Sets the reticle and die site origins
;#####################################################
defmethod( setReticleOrigin (( ret reticle ) arg)
  let((retOrig orig shx shy)
    retOrig = Origin(ret)
    shx = xCoord(arg)-xCoord(retOrig)
    shy = yCoord(arg)-yCoord(retOrig)
    shiftOrigin(ret list(shx shy))
    foreach(die getCollection(ret->dieSites)
      shiftOrigin(die list(shx shy))
    );foreach
  );let
);defmethod

;######################################################
;######################################################
;######################################################
