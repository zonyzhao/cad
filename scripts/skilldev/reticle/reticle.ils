;;;;;;;;;;;;;;;;;;;;;;;;;;;;;;;;;;;;;;;;;;;;;;;;;;;;;;;;;;;;;;;;;;;;;;;;;;;;;;;;
;;;;;;;;;;;;;;;;  reticle.il: Reticle Object
;;;;;;;;;;;;;;;;;;;;;;;;;;;;;;;;;;;;;;;;;;;;;;;;;;;;;;;;;;;;;;;;;;;;;;;;;;;;;;;;
defclass( reticle (cv)
	  (
		( srRes @reader getRes @writer setRes)
		( maxDim @reader getMaxDim @writer setMaxDim)
		( xynPadDie @reader getPadDie @writer setPadDie)
		( xynPadCoupon @reader getPadCoupon @writer setPadCoupon)
		( validDim @reader getDimValid)
		( validRes @reader getResValid)
		( dieList )
		( couponList )
	  )
) ; defClass

;#####################################################
; Constructor Method
;#####################################################
defmethod( initializeInstance @after ((obj reticle))
	   obj->srRes = nil
	   obj->maxDim = nil
	   obj->xynPadDie = nil
	   obj->xynPadCoupon = nil
	   obj->validDim = nil
	   obj->validRes = nil
	   obj->dieList = nil
	   obj->couponList = nil
);defmethod

;######################################################
; This method checks to make sure reticle width and
; height do not exceed the maximum dimension (maxDim)
;######################################################
defmethod( checkDim ((ret reticle))
  ret->validDim = 't
  getDim(ret)
  if(ret->bb->width > ret->maxDim then
    printf("ERROR: Reticle Width %8.1f exceeds maximum dimension %f\n" float(ret->bb->width) float(ret->maxDim) )
    ret->validDim = nil
  else
    printf("INFO: Reticle Width %8.1f is less than maximum dimension %f\n" float(ret->bb->width) float(ret->maxDim) )
  );if
  if(ret->bb->height > ret->maxDim then
    printf("ERROR: Reticle Length %8.1f exceeds maximum dimension %f\n" float(ret->bb->height) float(ret->maxDim) )
    ret->validDim = nil
  else
    printf("INFO: Reticle Length %8.1f is less than maximum dimension %f\n" float(ret->bb->height) float(ret->maxDim) )
  );if
);defmethod

;#####################################################
; This method checks the reticle's bbox dimensions
; (width and height) for grid requirements????
; FIXME: Get grid information from TF via grid class
;#####################################################
;defmethod( checkGrid ((ret reticle))
;  if( (ret->bb->width-floor(ret->bb->width)) > 0.0 then
;    printf("ERROR: Reticle width %g step resolution NOT ON a 1u grid\n" ret->bb->width)
;  else
;  );if
;  if( (ret->bb->height-floor(ret->bb->height)) > 0.0 then
;    printf("ERROR: Reticle width %g step resolution NOT ON a 1u grid\n" ret->bb->height)
;  else
;  );if
;);defmethod

;#####################################################
; This method checks the reticle's bbox dimensions
; (width and height) for Step and Repeat (S&R) value
; provided
;#####################################################
defmethod( checkRes (( ret reticle ))
    ret->validRes = 't
    getDim(ret)
    if( equal( modulo( int(ret->bb->width) ret->srRes) 0) then
      printf("INFO: Reticle Width %5.1f MEETS required S&R step resolution of %3.1f\n" float(ret->bb->width) float(ret->srRes))
    else
      printf("ERROR: Reticle Width %5.1f DOES NOT MEET required S&R step resolution of %3.1f\n" float(ret->bb->width) float(ret->srRes))
      ret->validRes = nil
    );if
    if( equal( modulo( int(ret->bb->height) ret->srRes) 0) then
      printf("INFO: Reticle Length %5.1f MEETS required S&R step resolution of %3.1f\n" float(ret->bb->height) float(ret->srRes))
    else
      printf("ERROR: Reticle Length %5.1f DOES NOT MEET required S&R step resolution of %3.1f\n" float(ret->bb->height) float(ret->srRes))
      ret->validRes = nil
    );if
); defmethod

;#####################################################
; This method checks the reticle's bbox dimensions
; (width and height) for Step and Repeat (S&R) value
; provided
;#####################################################
defmethod( chipId (( ret reticle ))
  nil
);

;#####################################################
; This method searches the reticle instances for the
; xynPad. It only searches for the pad in instances
; one level below the top level reticle cellview
;#####################################################
defmethod( findXynPads (( ret reticle ))
  let((dlist cv)
    dlist = '()
    clist = '()
    cv = getRef(ret)
    foreach( ih cv~>instHeaders
      printf("Instance Header Name: %s \n" ih~>cellName)
      foreach( inst ih~>instances
        printf("Instance Name: %s \n" inst~>cellName)
        foreach( cell inst~>master~>instances
          printf("Cell Name: %s \n" cell~>cellName)
          if(cell~>cellName == ret->xynPadDie then
            printf("XYN DIE PAD FOUND!: %s, In die: %s \n" cell~>cellName inst~>cellName)
	    dlist = cons(inst~>cellName dlist)
          );
	  if(cell~>cellName == ret->xynPadCoupon then
            printf("XYN COUPON PAD FOUND!: %s, In die: %s \n" cell~>cellName inst~>cellName)
	    clist = cons(inst~>cellName clist)
          );
        );foreach
      );foreach
    );foreach
    dlist = sort(dlist nil)
    clist = sort(clist nil)
    ret->dieList = dlist
    ret->couponList = clist
  );let
);defmethod

;;;;;;;;;;;;;;;;;;;;;;;;;;;;;;;;;;;;;;;;;;;;;;;;;;;;;;;;;;;;;;;;;;;;;;;;;;;;;;;;;
; Description: Sorts chips based on the whether the chip is a chip or a coupon,
;              then on the naming convention adopted on 06/08
;                    Chips/Legacy Coupons: NN[N]  (e.g.  99, 970)
;                    New Standard Coupons: PPNNR  (e.g. 8099A)
;                New Experimental Coupons: XPPNNR (e.g. X8001A)
;                         Legend -  N - Number
;                                   P - Process
;                                   R - Revision
;                                  [] - Optional
;;;;;;;;;;;;;;;;;;;;;;;;;;;;;;;;;;;;;;;;;;;;;;;;;;;;;;;;;;;;;;;;;;;;;;;;;;;;;;;;;

;#####################################################
; Digitizes a number (num) to a list of digits of
; length digits
;#####################################################
defmethod( digitize (( ret reticle ) num)
  let((digits format dlist)
    ;FIXME: add a second argument for digits
    digits = 3
    format = sprintf( nil "%%0%dd" digits)
    dlist = parseString( sprintf( nil format num) "")
  );let
);defmethod

;######################################################
;######################################################
;######################################################
