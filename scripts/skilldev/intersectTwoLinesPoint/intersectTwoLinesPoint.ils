;;;;;;;;;;;;;;;;;;;;;;;;;;;;;;;;;;;;;;;;;;;;;;;;;;;;;;;;;;;;;;;;;;;;;;;;;;;;;;;;;
; intersectTwoLinesPoint.ils: class representing the point where two lines
;                             intersect
;;;;;;;;;;;;;;;;;;;;;;;;;;;;;;;;;;;;;;;;;;;;;;;;;;;;;;;;;;;;;;;;;;;;;;;;;;;;;;;;;
defclass( intersectTwoLinesPoint ( point )
  (
	( L1 @initarg L1 )
	( L2 @initarg L2 )
  )
);defclass
;;;;;;;;;;;;;;;;;;;;;;;;;;;;;;;;;;;;;;;;;;;;;;;;;;;;;;;;;;;;;;;;;;;;;;;;;;;;;;;;;
;
;;;;;;;;;;;;;;;;;;;;;;;;;;;;;;;;;;;;;;;;;;;;;;;;;;;;;;;;;;;;;;;;;;;;;;;;;;;;;;;;;
defmethod( Describe (( obj intersectTwoLinesPoint  ))
  callNextMethod( obj ) ;;; calls method of generic superclass point description
  printf( "...intersection of\n")
  Describe( obj->L1 )
  Describe( obj->L2 )
);defmethod
;;;;;;;;;;;;;;;;;;;;;;;;;;;;;;;;;;;;;;;;;;;;;;;;;;;;;;;;;;;;;;;;;;;;;;;;;;;;;;;;;
;
;;;;;;;;;;;;;;;;;;;;;;;;;;;;;;;;;;;;;;;;;;;;;;;;;;;;;;;;;;;;;;;;;;;;;;;;;;;;;;;;;
procedure( make_intersectTwoLinesPoint( line1 line2)
  let( (point)
    point = makeInstance( 'IntersectionTwoLines_Point ?L1 line1 ?L2 line2)
    Update( point )
    Connect( line1 point )
    Connect( line2 point )
    point
  );let
);procedure
;;;;;;;;;;;;;;;;;;;;;;;;;;;;;;;;;;;;;;;;;;;;;;;;;;;;;;;;;;;;;;;;;;;;;;;;;;;;;;;;;
;
;;;;;;;;;;;;;;;;;;;;;;;;;;;;;;;;;;;;;;;;;;;;;;;;;;;;;;;;;;;;;;;;;;;;;;;;;;;;;;;;;
defmethod( Validate (( obj intersectTwoLinesPoint ))
  let( (A1 B1 C1 A2 B2 C2 x y)
    A1 = obj->L1->A
    B1 = obj->L1->B
    C1 = obj->L1->C
    A2 = obj->L2->A
    B2 = obj->L2->B
    C2 = obj->L2->C
    x = obj->x
    y = obj->y
    when( A1*x+B1*y+C1 != 0.0 || A2*x+B2*y+C2 != 0.0
      error("Invalid intersectTwoLinesPoint\n")
    );when
    t
  );let
);defmethod
;;;;;;;;;;;;;;;;;;;;;;;;;;;;;;;;;;;;;;;;;;;;;;;;;;;;;;;;;;;;;;;;;;;;;;;;;;;;;;;;;
; check to see if two lines have values ...
;;;;;;;;;;;;;;;;;;;;;;;;;;;;;;;;;;;;;;;;;;;;;;;;;;;;;;;;;;;;;;;;;;;;;;;;;;;;;;;;;
defmethod( Update (( obj  intersectTwoLinesPoint ))
  ;printf("Figure out x & y from lines %L %L\n" obj->L1 obj->L2)
  let( (A1 B1 C1 A2 B2 C2 det )
    A1 = obj->L1->A
    B1 = obj->L1->B
    C1 = obj->L1->C
    A2 = obj->L2->A
    B2 = obj->L2->B
    C2 = obj->L2->C
    det = A1*B2-A2*B1
    when( det == 0.0
      error("Can not intersect two parallel lines\n")
    );when
    obj->x = ((-C1)*B2-(-C2)*B1)*1.0/det
    obj->y = (A1*(-C2)-A2*(-C1))*1.0/det
  );let
  callNextMethod( obj )
);defmethod
;;;;;;;;;;;;;;;;;;;;;;;;;;;;;;;;;;;;;;;;;;;;;;;;;;;;;;;;;;;;;;;;;;;;;;;;;;;;;;;;;
;;;;;;;;;;;;;;;;;;;;;;;;;;;;;;;;;;;;;;;;;;;;;;;;;;;;;;;;;;;;;;;;;;;;;;;;;;;;;;;;;
;;;;;;;;;;;;;;;;;;;;;;;;;;;;;;;;;;;;;;;;;;;;;;;;;;;;;;;;;;;;;;;;;;;;;;;;;;;;;;;;;
