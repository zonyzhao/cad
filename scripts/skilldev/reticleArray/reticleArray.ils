;;;;;;;;;;;;;;;;;;;;;;;;;;;;;;;;;;;;;;;;;;;;;;;;;;;;;;;;;;;;;;;;;;;;;;;;;;;;;;;;
;  reticleArray.ils: Reticle Array Class
;;;;;;;;;;;;;;;;;;;;;;;;;;;;;;;;;;;;;;;;;;;;;;;;;;;;;;;;;;;;;;;;;;;;;;;;;;;;;;;;
defclass( reticleArray (cv)
  (
    ( waferWidth @reader getWaferWidth @writer setWaferWidth)
    ( waferHeight @reader getWaferHeight @writer setWaferHeight)
    ( reticle @reader getReticle @writer setReticle)
    ( reticles @reader getReticles)
    ( arrayWidth @reader getArrayWidth @writer setArrayWidth)
    ( arrayHeight @reader getArrayHeight @writer setArrayHeight)
    ( rows @reader getRows @writer setRows)
    ( cols @reader getCols @writer setCols)
    ( overlap @reader getOverlap @writer setOverlap)
    ( origin )
    ( ur )
  )
);defclass
;#####################################################
; Constructor Method
;#####################################################
defmethod( initializeInstance @after ((obj reticleArray))
  obj->waferWidth = nil
  obj->waferHeight = nil
  obj->reticle = nil
  obj->reticles = makeInstance( 'collection )
  obj->arrayWidth = nil
  obj->arrayHeight = nil
  obj->rows = nil
  obj->cols = nil
  obj->overlap = nil
  obj->origin = nil
  obj->ur = nil
);defmethod
;;;;;;;;;;;;;;;;;;;;;;;;;;;;;;;;;;;;;;;;;;;;;;;;;;;;;;;
; Center the reticle array
; FIXME: need to generate an reticle array that has
;        an odd number of sites in the horizontal and
;        vertical. This will center the center of the
;        center site on the center of the wafer outline
;;;;;;;;;;;;;;;;;;;;;;;;;;;;;;;;;;;;;;;;;;;;;;;;;;;;;;;
defmethod( centerArray (( ra reticleArray ) arg)
  let((w h cx cy shx shy)
    w  = xCoord(ra->ur) - xCoord(ra->origin)
    h  = yCoord(ra->ur) - yCoord(ra->origin)
    cx = (w - xCoord(ra->origin))/2.0
    cy = (h - yCoord(ra->origin))/2.0
    shx = cx - xCoord(arg)
    shy = cy - yCoord(arg)
    shift(ra list(-w/2.0 -h/2.0))
    ra->width = w
    ra->height = h
    ra->origin = list(-w/2.0 -h/2.0)
    ra->ur = list(w/2.0 h/2.0)
  );let
);defmethod
;;;;;;;;;;;;;;;;;;;;;;;;;;;;;;;;;;;;;;;;;;;;;;;;;;;;;;;
; Shift entire reticle array origin to the new origin
; given by arg
;;;;;;;;;;;;;;;;;;;;;;;;;;;;;;;;;;;;;;;;;;;;;;;;;;;;;;;
defmethod( shift (( ra reticleArray ) arg)
  let((orig dx dy i)
    i = 0
    foreach(ret getCollection(ra->reticles)
      orig = getOrigin(ret)
      dx = xCoord(orig) + xCoord(arg)
      dy = yCoord(orig) + yCoord(arg)
      printf("INFO(reticleArray) Setting Origin %d to %L\n" i list(dx dy))
      setReticleOrigin(ret list(dx dy))
      i++
    );foreach
  );let
);defmethod
;;;;;;;;;;;;;;;;;;;;;;;;;;;;;;;;;;;;;;;;;;;;;;;;;;;;;;;
;######################################################
; Create Reticle Array
;######################################################
defmethod( array (( ra reticleArray ))
  let((ral rah rw rh r c ind x y)
    ral = getWaferWidth(ra)
    rah = getWaferHeight(ra)
    rw = getWidth(ra->reticle)
    rh = getHeight(ra->reticle)
    r = floor(ral/rh)
    c = floor(rah/rw)
    ra->rows = r
    ra->cols = c
    ol = ra->overlap
    ind = 0
    x = 0.0
    y = 0.0
    for(i 0 sub1(r)
      ind = ind + ind*i
      x = 0.0
      orig = list(x y)
      for(j 0 sub1(c)
        ind = ind + j
	x = xCoord(orig) + rw - ol
	ret = makeInstance( 'reticle )
	cloneRet(ra->reticle ret)
	setReticleOrigin(ret orig)
        add(ra->reticles ret)
	orig = list(x y)
      );for
      y = yCoord(orig) + rh - ol
    );for
    ra->origin = list(0.0 0.0)
    ra->ur = list(x y)
    list(ra->rows ra->cols)
  );let
);defmethod
;######################################################
; Render reticle boundary box array
;######################################################
defmethod( render (( ra reticleArray ))
  foreach(ret getCollection(ra->reticles)
    printf("Reticle Origin: (%f,%f)\n" xCoord(ret->origin) yCoord(ret->origin))
    setRef(ret getRef(ra))
    renderRetBbox(ret)
  );foreach
);defmethod
;######################################################
; Erase reticle boundary box array
;######################################################
defmethod( erase (( ra reticleArray ))
  let((cv)
    cv = getRef(ra)
    if(!null(cv~>shapes) then
      foreach( shape cv~>shapes
        if(shape~>layerName == "GRID" then
          dbDeleteObject(shape)
        );if
      );foreach
    );if
  );let
);defmethod
;######################################################
; Render the boundary box of a single reticle into
; the target cellview
;######################################################
defmethod( renderBbox (( ra reticleArray ))
  let((ind ret r c)
    ra->rows = r
    ra->cols = c
    ind = 0.0
    for(i 0 sub1(r)
      ind = ind + ind*i
      for(j 0 sub1(c)
        ind = ind + j
        ret = getItem(reticles ind)
	renderRetBbox(ret)
      );for
    );for
  );let
);defmethod
;######################################################
;######################################################
;######################################################
