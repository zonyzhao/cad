;;;;;;;;;;;;;;;;;;;;;;;;;;;;;;;;;;;;;;;;;;;;;;;;;;;;;;;;;;;;;;;;;;;;;;;;;;;;;;;;
;  wafer.il: Wafer Class
;;;;;;;;;;;;;;;;;;;;;;;;;;;;;;;;;;;;;;;;;;;;;;;;;;;;;;;;;;;;;;;;;;;;;;;;;;;;;;;;
defclass( wafer (cv)
  (
    ( width @read getWidth @writer setWidth)
    ( height @read getHeight @writer setHeight )
    ( overlap @read getOverlap @writer setOverlap )
    ( retName @reader getRetName @writer setRetName)
    ( retArray @reader getRetArray)
    ( crossLayer @reader getCrossLayer @writer setCrossLayer)
    ( center @reader getCenter )
    ( shiftHorizontal @reader getShiftHorizontal )
    ( shiftVerticle @reader getShiftVerticle )
    ( pm @reader getPm )
    ( wafNumMrk @reader getWafNumMrk )
    ( retNumMrk @reader getRefNumMrk )
    ( bsideMrk @reader getBsideMrk )
  )
);defClass

;#####################################################
; Constructor Method
;#####################################################
defmethod( initializeInstance @after ((obj wafer))
  obj->width = nil
  obj->height = nil
  obj->overlap = nil
  obj->retName = nil
  obj->retArray = makeInstance( 'reticleArray )
  obj->crossLayer = "GLASS"
  obj->center = nil
  obj->shiftHorizontal = nil
  obj->shiftVerticle = nil
  obj->pm = makeInstance( 'collection )
  obj->wafNumMrk = makeInstance( 'collection )
  obj->retNumMrk = makeInstance( 'collection )
  obj->bsideMrk =  makeInstance( 'collection )
);defmethod

;######################################################
; This finds the Center Diameter "CD-Critical Dimension"
; Cross Coordinates
; find the center of the wafer outline, it's a cross
; (on GRID layer, typically):
; FIXME: zero centered cross measures an offset!
;######################################################
defmethod( findCenter (( waf wafer ))
  let( (shapes cross x y)
    shapes = setof( i getRef(waf)~>shapes i~>layerName == waf->crossLayer)
    cross = nth(0 shapes)
    if(length(cross~>points) == 12 then
      x = (caadr(cross~>bBox)-caar(cross~>bBox))/2.0
      y = (cadadr(cross~>bBox)-cadar(cross~>bBox))/2.0
    );if
    waf->center = list(x y)
  );let
);defmethod
;;;;;;;;;;;;;;;;;;;;;;;;;;;;;;;;;;;;;;;;;;;;;;;;;;;;;;;;
; Read in the wafer outline layers from a reference
; cellview
;;;;;;;;;;;;;;;;;;;;;;;;;;;;;;;;;;;;;;;;;;;;;;;;;;;;;;;;
defmethod( renderOutline (( waf wafer ) cv)
  let((ss)
    ss = makeInstance( 'snapshot )
    setRef(ss cv)
    getStackUp(ss)
    setRef(ss getRef(waf))
    renderStack(ss)
  );let
);defmethod
;;;;;;;;;;;;;;;;;;;;;;;;;;;;;;;;;;;;;;;;;;;;;;;;;;;;;;;;
;######################################################
;######################################################
;######################################################
