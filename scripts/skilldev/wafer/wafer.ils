;;;;;;;;;;;;;;;;;;;;;;;;;;;;;;;;;;;;;;;;;;;;;;;;;;;;;;;;;;;;;;;;;;;;;;;;;;;;;;;;
;  wafer.il: Wafer Class
;;;;;;;;;;;;;;;;;;;;;;;;;;;;;;;;;;;;;;;;;;;;;;;;;;;;;;;;;;;;;;;;;;;;;;;;;;;;;;;;
defclass( wafer (cv)
  (
    ( width @read getWidth @writer setWidth)
    ( height @read getHeight @writer setHeight )
    ( overlap @read getOverlap @writer setOverlap )
    ( retName @reader getRetName @writer setRetName)
    ( retArray @reader getRetArray)
    ( crossLayer @reader getCrossLayer @writer setCrossLayer)
    ( center @reader getCenter )
    ( shiftHorizontal @reader getShiftHorizontal )
    ( shiftVerticle @reader getShiftVerticle )
    ( pm @reader getPm )
    ( wafNumMrk @reader getWafNumMrk )
    ( retNumMrk @reader getRefNumMrk )
    ( bsideMrk @reader getBsideMrk )
    ( dieSiteRows @reader getDieSiteRows )
    ( dieSiteCols @reader getDieSiteCols )
  )
);defClass

;#####################################################
; Constructor Method
;#####################################################
defmethod( initializeInstance @after ((obj wafer))
  obj->width = nil
  obj->height = nil
  obj->overlap = nil
  obj->retName = nil
  obj->retArray = makeInstance( 'reticleArray )
  obj->crossLayer = "GLASS"
  obj->center = nil
  obj->shiftHorizontal = nil
  obj->shiftVerticle = nil
  obj->pm = makeInstance( 'collection )
  obj->wafNumMrk = makeInstance( 'collection )
  obj->retNumMrk = makeInstance( 'collection )
  obj->bsideMrk =  makeInstance( 'collection )
);defmethod

;######################################################
; This finds the Center Diameter "CD-Critical Dimension"
; Cross Coordinates
; find the center of the wafer outline, it's a cross
; (on GRID layer, typically):
; FIXME: zero centered cross measures an offset!
;######################################################
defmethod( findCenter (( waf wafer ))
  let( (shapes cross x y)
    shapes = setof( i getRef(waf)~>shapes i~>layerName == waf->crossLayer)
    cross = nth(0 shapes)
    if(length(cross~>points) == 12 then
      x = (caadr(cross~>bBox)-caar(cross~>bBox))/2.0
      y = (cadadr(cross~>bBox)-cadar(cross~>bBox))/2.0
    );if
    waf->center = list(x y)
  );let
);defmethod
;;;;;;;;;;;;;;;;;;;;;;;;;;;;;;;;;;;;;;;;;;;;;;;;;;;;;;;;
; Read in the wafer outline layers from a reference
; cellview
;;;;;;;;;;;;;;;;;;;;;;;;;;;;;;;;;;;;;;;;;;;;;;;;;;;;;;;;
defmethod( renderOutline (( waf wafer ) cv)
  let((ss)
    ss = makeInstance( 'snapshot )
    setRef(ss cv)
    getStackUp(ss)
    setRef(ss getRef(waf))
    renderStack(ss)
  );let
);defmethod
;;;;;;;;;;;;;;;;;;;;;;;;;;;;;;;;;;;;;;;;;;;;;;;;;;;;;;;;
; Get the information about the wafer level die site
; array
;;;;;;;;;;;;;;;;;;;;;;;;;;;;;;;;;;;;;;;;;;;;;;;;;;;;;;;;
defmethod( getWaferDieSites (( waf wafer ))
  let((rrows rcols drows dcols rind dind ret die wrow wcol)
      rrows = getRows(waf->retArray)
      rcols = getCols(waf->retArray)
      drows = xCoord(getDieSiteArray(waf->retArray->reticle))
      dcols = yCoord(getDieSiteArray(waf->retArray->reticle))
      waf->dieSiteRows = rrows*drows
      waf->dieSiteCols = rcols*dcols
      wrow = 0
      wcol = 0
      for(i 0 sub1(rrows)
      	wrow = wrow + i*drows
        for(j 0 sub1(rcols)
	  wrow = wrow + j*dcols
	  rind = i + j
          ret = getItem(waf->retArray->reticles rind)
	  for(k 0 sub1(drows)
	    wrow = wrow++
	    for(l 0 sub1(dcols)
	      wcol = wcol++
	      dind = k + l
	      die = getItem(ret->dieSites dind)
	      setWaferRow(die wrow)
	      setWaferCol(die wcol)
	    );for
          );for
        );for
      );for
      list(waf->dieSiteRows waf->dieSiteCols)
  );let
);defmethod

;;;;;;;;;;;;;;;;;;;;;;;;;;;;;;;;;;;;;;;;;;;;;;;;;;;;;;;;
; Get the information about the wafer level die site
; array
;;;;;;;;;;;;;;;;;;;;;;;;;;;;;;;;;;;;;;;;;;;;;;;;;;;;;;;;
defmethod( numberDieSites (( waf wafer ))
  let(()
    ; based upon the number of cols/rows determine the
    ; number of digits necessary to represent the row/col
    ; numbers
    for(i 0 sub1(getDieSiteRows)
      for(j 0 sub1(getDieSiteCols)
         ;
         ; print a dash in middle of numpad
	 ; print row number to left of dash
	 ; print col number to right of dash
      );for
    );for
  );let
);defmethod

;;;;;;;;;;;;;;;;;;;;;;;;;;;;;;;;;;;;;;;;;;;;;;;;;;;;;;;;
;######################################################
;######################################################
;######################################################
