;;;;;;;;;;;;;;;;;;;;;;;;;;;;;;;;;;;;;;;;;;;;;;;;;;;;;;;;;;;;;;;;;;;;;;;;;;;;;;;;
;  wafer.il: Wafer Class
;;;;;;;;;;;;;;;;;;;;;;;;;;;;;;;;;;;;;;;;;;;;;;;;;;;;;;;;;;;;;;;;;;;;;;;;;;;;;;;;
defclass( wafer (cv)
  (
    ( width @read getWidth @writer setWidth)
    ( height @read getHeight @writer setHeight )
    ( overlap @read getOverlap @writer setOverlap )
    ( retName @reader getRetName @writer setRetName)
    ( retArray @reader getRetArray)
    ( crossLayer @reader getCrossLayer @writer setCrossLayer)
    ( center @reader getCenter )
    ( shiftHorizontal @reader getShiftHorizontal )
    ( shiftVerticle @reader getShiftVerticle )
    ( pm @reader getPm )
    ( wafNumMrk @reader getWafNumMrk )
    ( retNumMrk @reader getRefNumMrk )
    ( bsideMrk @reader getBsideMrk )
    ( dieSiteRows @reader getDieSiteRows )
    ( dieSiteCols @reader getDieSiteCols )
    ( waferOutline )
    ( exclusingRing )
    ( tempCv )
  )
);defClass

;#####################################################
; Constructor Method
;#####################################################
defmethod( initializeInstance @after ((obj wafer))
  obj->width = nil
  obj->height = nil
  obj->overlap = nil
  obj->retName = nil
  obj->retArray = makeInstance( 'reticleArray )
  obj->crossLayer = "GLASS"
  obj->center = nil
  obj->shiftHorizontal = nil
  obj->shiftVerticle = nil
  obj->pm = makeInstance( 'collection )
  obj->wafNumMrk = makeInstance( 'collection )
  obj->retNumMrk = makeInstance( 'collection )
  obj->bsideMrk =  makeInstance( 'collection )
  obj->waferOutline = makeInstance( 'shape)
  obj->exclusingRing = makeInstance( 'shape )
  obj->tempCv = makeInstance( 'cv )
);defmethod

;######################################################
; This finds the Center Diameter "CD-Critical Dimension"
; Cross Coordinates
; find the center of the wafer outline, it's a cross
; (on GRID layer, typically):
; FIXME: zero centered cross measures an offset!
;######################################################
defmethod( findCenter (( waf wafer ))
  let( (shapes cross x y)
    shapes = setof( i getRef(waf)~>shapes i~>layerName == waf->crossLayer)
    cross = nth(0 shapes)
    if(length(cross~>points) == 12 then
      x = (caadr(cross~>bBox)-caar(cross~>bBox))/2.0
      y = (cadadr(cross~>bBox)-cadar(cross~>bBox))/2.0
    );if
    waf->center = list(x y)
  );let
);defmethod
;;;;;;;;;;;;;;;;;;;;;;;;;;;;;;;;;;;;;;;;;;;;;;;;;;;;;;;;
; Read in the wafer outline layers from a reference
; cellview
;;;;;;;;;;;;;;;;;;;;;;;;;;;;;;;;;;;;;;;;;;;;;;;;;;;;;;;;
defmethod( renderOutline (( waf wafer ) cv)
  let((ss)
    ss = makeInstance( 'snapshot )
    setRef(ss cv)
    getStackUp(ss)
    setRef(ss getRef(waf))
    renderStack(ss)
  );let
);defmethod
;;;;;;;;;;;;;;;;;;;;;;;;;;;;;;;;;;;;;;;;;;;;;;;;;;;;;;;;
; Get the information about the wafer level die site
; array
;;;;;;;;;;;;;;;;;;;;;;;;;;;;;;;;;;;;;;;;;;;;;;;;;;;;;;;;
defmethod( getWaferDieSites (( waf wafer ))
  let((rarows racols dsrows dscols rind dind ret die wrow wcol dsn)
      rarows = getRows(waf->retArray)
      racols = getCols(waf->retArray)
      dsrows = xCoord(getDieSiteArray(waf->retArray->reticle))
      dscols = yCoord(getDieSiteArray(waf->retArray->reticle))
      waf->dieSiteRows = rarows*dsrows
      waf->dieSiteCols = racols*dscols
      printf("INFO(wafer): Total Number of Wafer Die Sites: %d\n" rarows*dsrows*racols*dscols)
      wcol = 0
      dsn  = 0
      wrow = 0
      for(i 0 sub1(rarows)
        dind = 0
	for(j 0 sub1(dsrows)
          wcol = 0
	  for(k 0 sub1(racols)
	    rind = i*rarows + k
	    ret = getItem(waf->retArray->reticles rind)
	    setWaferRow(ret i)
	    setWaferCol(ret k)
	    for(l 0 sub1(dscols)
	      dind = j*dsrows+l
              die = getItem(ret->dieSites dind)
	      setWaferRow(die wrow)
	      setWaferCol(die wcol)
	      println("##########################################################################################")
	      printf("INFO(wafer): Numbering Wafer Die Site #%d, ROW: %d, COL: %d\n" dsn wrow wcol)
	      printf("INFO(wafer): Reticle Array Index: ROW %d, COL %d | Die Array Index: ROW %d, COL %d\n" i k j l)
	      dsn++
	      wcol++
	    );for
          );for
	  wrow++
        );for
      );for
      list(waf->dieSiteRows waf->dieSiteCols)
  );let
);defmethod
;;;;;;;;;;;;;;;;;;;;;;;;;;;;;;;;;;;;;;;;;;;;;;;;;;;;;;;;
; Print the die site numbers across the wafer
;;;;;;;;;;;;;;;;;;;;;;;;;;;;;;;;;;;;;;;;;;;;;;;;;;;;;;;;
defmethod( numberDieSites (( waf wafer ))
  let((ret)
    ; based upon the number of cols/rows determine the
    ; number of digits necessary to represent the row/col
    ; numbers
    ;
    ; open the target wafer cellview for applying the numbers
    ;
    ; get each reticle in the wafer reticle array
;    getWaferRow(getItem(ret->dieSites 0))
;    ret = getItem(waf->retArray->reticles 0)
    ; get each die within the indexed reticle
;    for(i 0 sub1(getDieSiteRows)
;      for(j 0 sub1(getDieSiteCols)
         ; update pad center
;	 update(die)

         ; print a dash in middle of numpad
	 ; print row number to left of dash
	 ; print col number to right of dash
;      );for
;    );for
  );let
);defmethod

;;;;;;;;;;;;;;;;;;;;;;;;;;;;;;;;;;;;;;;;;;;;;;;;;;;;;;;;;;;;;;;;;;;;;;;;;
; Determines if the bbox of a site is valid
;
; 1.) Create a shape from the bbox argument
; 2.) First check to see if the bbox is fully within the wafer
;     boundaries by a set amount (1/4 of the exclusion ring width)
;     This is done by checking the distance of each corner of the bbox
;     from the center of the wafer. The wafer center is determined from
;     the bbox of the wafer overlay/outline
;;;;;;;;;;;;;;;;;;;;;;;;;;;;;;;;;;;;;;;;;;;;;;;;;;;;;;;;;;;;;;;;;;;;;;;;;
defmethod( isValidSite (( waf wafer ) bbox)
  let((shp)
    shp = dbCreateRect( waf->tempCv "text" bbox)
    and(
	 overlaping( shp waf->waferOutline)
	 null( xynOverlaps(shp  waf->exclusingRing))
    );and
  );let
);defmethod

;;;;;;;;;;;;;;;;;;;;;;;;;;;;;;;;;;;;;;;;;;;;;;;;;;;;;;;;;;;;;;;;;;;;;;;;;
; Determines if the given bBox overlaps a given shape
; Converts the bBox to a shape on the text layer uses the
; layout editor function "leLayerAnd" funtion to determine if there
; is an intersection or overlap between the bBox and shape
; arguments.
;
; 1.) Copy the two input shapes into the temporary cellview
; 2.) Perform the boolean and on the two shapes and return
;     the result to the text layer
; 3.) Clean up the temporary cell view by removing all shapes
;     on the input argument shape layers making it clean for
;     the next overlap operation
;;;;;;;;;;;;;;;;;;;;;;;;;;;;;;;;;;;;;;;;;;;;;;;;;;;;;;;;;;;;;;;;;;;;;;;;;
defmethod( isOverlapping (( waf wafer ) shapeA shapeB)
  let((layA layB layC result lpp)
    dbCopyFig( getShape(shapeA) waf->tempCv)
    dbCopyFig( getShape(shapeB) waf->tempCv)
    layA = getLayer(shapeA)
    layB = getLayer(shapeB)
    layC = "text"
    result = leLayerAnd(waf->tempCv list( layA getPurpose(shapeA))
			   list( layB Purpose(shapeB))
			   list( layC "drawing"))
    ; Delete all shapes on the layers above in the temporary cellview
    foreach( layerName '( layA layB layC)
      lpp = car( exists( l (waf->tempCv~>layerPurposePairs l~>layerName == layerName))
      foreach( shape lpp~>shapes
        dbDeleteObject( shape))
      )
    )
    result
  );let
);defmethod
;;;;;;;;;;;;;;;;;;;;;;;;;;;;;;;;;;;;;;;;;;;;;;;;;;;;;;;;
;######################################################
;######################################################
;######################################################
