;;;;;;;;;;;;;;;;;;;;;;;;;;;;;;;;;;;;;;;;;;;;;;;;;;;;;;;;;;;;;;;;;;;;;;;;;;;;;;;;
;  wafer.il: Wafer Class
;;;;;;;;;;;;;;;;;;;;;;;;;;;;;;;;;;;;;;;;;;;;;;;;;;;;;;;;;;;;;;;;;;;;;;;;;;;;;;;;
defclass( wafer (cv)
  (
    ( width @read getWidth @writer setWidth)
    ( height @read getHeight @writer setHeight )
    ( overlap @read getOverlap @writer setOverlap )
    ( retName @reader getRetName @writer setRetName)
    ( reticle @reader getReticle @writer setReticle )
    ( reticles @reader getReticles)
    ( rows @reader getRows @writer setRows)
    ( cols @read getCols @writer setCols)
    ( crossLayer @reader getCrossLayer @writer setCrossLayer)
    ( center @reader getCenter )
    ( shiftHorizontal @reader getShiftHorizontal )
    ( shiftVerticle @reader getShiftVerticle )
    ( pm @reader getPm )
    ( wafNumMrk @reader getWafNumMrk )
    ( retNumMrk @reader getRefNumMrk )
    ( bsideMrk @reader getBsideMrk )
  )
);defClass

;#####################################################
; Constructor Method
;#####################################################
defmethod( initializeInstance @after ((obj wafer))
  obj->width = nil
  obj->height = nil
  obj->overlap = nil
  obj->retName = nil
  obj->reticle = nil
  obj->reticles = makeInstance( 'collection )
  obj->rows = nil
  obj->cols = nil
  obj->crossLayer = "GRID"
  obj->center = nil
  obj->shiftHorizontal = nil
  obj->shiftVerticle = nil
  obj->pm = makeInstance( 'collection )
  obj->wafNumMrk = makeInstance( 'collection )
  obj->retNumMrk = makeInstance( 'collection )
  obj->bsideMrk =  makeInstance( 'collection )
);defmethod

;######################################################
; This finds the Center Diameter "CD-Critical Dimension"
; Cross Coordinates
; find the center of the wafer outline, it's a cross
; (on GRID layer, typically):
;######################################################
defmethod( findCenter (( waf wafer ))
  let( (shapes cross)
    shapes = setof( i getRef(waf)~>shapes i~>layerName == waf->crossLayer)
    cross = nth(0 shapes)
    if(length(cross~>points) == 12 then
      waf->center = abs((caadr(cross~>bBox)-caar(cross~>bBox))-(cadadr(cross~>bBox)-cadar(cross~>bBox)))
    );if
    waf->center
  );let
);defmethod

;######################################################
; Create Reticle Array
;######################################################
defmethod( array (( waf wafer ))
  let((ww wh rw rh r c ind x y)
    ww = waf->width
    wh = waf->height
    rw = getWidth(waf->reticle)
    rh = getHeight(waf->reticle)
    r = floor(wh/rh)
    c = floor(ww/rw)
    waf->rows = r
    waf->cols = c
    ol = waf->overlap
    ind = 0
    x = 0.0
    y = 0.0
    for(i 0 sub1(r)
      ind = ind + ind*i
      x = 0.0
      orig = list(x y)
      for(j 0 sub1(c)
        ind = ind + j
	x = xCoord(orig) + rw - ol
	ret = makeInstance( 'reticle )
	cloneRet(waf->reticle ret)
	setOrigin(ret orig)
        add(waf->reticles ret)
	orig = list(x y)
      );for
      y = yCoord(orig) + rh - ol
    );for
    list(waf->rows waf->cols)
  );let
);defmethod

;######################################################
; Raster the reticle array in the upper right quadrant
;######################################################
defmethod( renderBbox (( waf wafer ))
  let((ind ret r c)
    waf->rows = r
    waf->cols = c
    ind = 0.0
    for(i 0 sub1(r)
      ind = ind + ind*i
      for(j 0 sub1(c)
        ind = ind + j
        ret = getItem(reticles ind)
	renderRetBbox(ret)
      );for
    );for
  );let
);defmethod
;######################################################
;######################################################
;######################################################
