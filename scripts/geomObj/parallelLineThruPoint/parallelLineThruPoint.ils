;;;;;;;;;;;;;;;;;;;;;;;;;;;;;;;;;;;;;;;;;;;;;;;;;;;;;;;;;;;;;;;;;;;;;;;;;;
; parallelLineThruPoint.ils
;;;;;;;;;;;;;;;;;;;;;;;;;;;;;;;;;;;;;;;;;;;;;;;;;;;;;;;;;;;;;;;;;;;;;;;;;;
defclass( parallelLineThruPoint ( line )
  (
	( P @initarg P)
	( L @intiarg L)
  )
);defclass

;;;;;;;;;;;;;;;;;;;;;;;;;;;;;;;;;;;;;;;;;;;;;;;;;;;;;;;;;;;;;;;;;;;;;;;;;;
;
;;;;;;;;;;;;;;;;;;;;;;;;;;;;;;;;;;;;;;;;;;;;;;;;;;;;;;;;;;;;;;;;;;;;;;;;;;
defmethod( Validate (( obj parallelLineThruPoint ))
  let( (x1 y1 A B C LA LB LC)
       x1 = obj->P->x
       y1 = obj->P->y
       LA = obj->L->A
       LB = obj->L->B
       LC = obj->L->C
       A = obj->A
       B = obj->B
       C = obj->C
       when( A*LB-LA*B != 0.0 || A*x1+B*y1+C != 0
         error("Invalid parallelLineThruPoint\n")
       );when
       t
  );let
);defmethod

;;;;;;;;;;;;;;;;;;;;;;;;;;;;;;;;;;;;;;;;;;;;;;;;;;;;;;;;;;;;;;;;;;;;;;;;;;
;
;;;;;;;;;;;;;;;;;;;;;;;;;;;;;;;;;;;;;;;;;;;;;;;;;;;;;;;;;;;;;;;;;;;;;;;;;;
defmethod( Describe (( obj parallelLineThruPoint ))
  callNextMethod( obj )
  printf("...Containing\n")
  Describe( obj->P )
  printf("...Parallel to\n")
  Describe( obj->L )
);defmethod

;;;;;;;;;;;;;;;;;;;;;;;;;;;;;;;;;;;;;;;;;;;;;;;;;;;;;;;;;;;;;;;;;;;;;;;;;;
;
;;;;;;;;;;;;;;;;;;;;;;;;;;;;;;;;;;;;;;;;;;;;;;;;;;;;;;;;;;;;;;;;;;;;;;;;;;
procedure( make_parallelLineThruPoint( point line )
  let( (parallel_line)
    parallel_line = makeInstance('ParallelLineThroughPoint_Line
				 ?P point
				 ?L line)
    Update( parallel_line )
    Connect( point parallel_line )
    Connect( line parallel_line )
    parallel_line
  );let
);procedure

;;;;;;;;;;;;;;;;;;;;;;;;;;;;;;;;;;;;;;;;;;;;;;;;;;;;;;;;;;;;;;;;;;;;;;;;;;
;
;;;;;;;;;;;;;;;;;;;;;;;;;;;;;;;;;;;;;;;;;;;;;;;;;;;;;;;;;;;;;;;;;;;;;;;;;;
defmethod( Update (( obj parallelLineThruPoint ))
  let( (A B C x1 y1 )
       A=obj->L->A
       B=obj->L->B
       C=obj->L->C
       x1=obj->P->x
       y1=obj->P->y
       obj->A=A
       obj->B=B
       obj->C=-(A*x1+B*y1)
  );let
);defmethod

;;;;;;;;;;;;;;;;;;;;;;;;;;;;;;;;;;;;;;;;;;;;;;;;;;;;;;;;;;;;;;;;;;;;;;;;;;
;;;;;;;;;;;;;;;;;;;;;;;;;;;;;;;;;;;;;;;;;;;;;;;;;;;;;;;;;;;;;;;;;;;;;;;;;;
;;;;;;;;;;;;;;;;;;;;;;;;;;;;;;;;;;;;;;;;;;;;;;;;;;;;;;;;;;;;;;;;;;;;;;;;;;
