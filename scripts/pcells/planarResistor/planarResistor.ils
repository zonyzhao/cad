;;;;;;;;;;;;;;;;;;;;;;;;;;;;;;;;;;;;;;;;;;;;;;;;;;;;;;;;;;;;;;;;;;;;;;;;;;;;;;;;
;;;;;;;;;;;;;;;;  list.il: Some extensions to skill list functionality
;;;;;;;;;;;;;;;;;;;;;;;;;;;;;;;;;;;;;;;;;;;;;;;;;;;;;;;;;;;;;;;;;;;;;;;;;;;;;;;;
defclass( planarResistor (PcellParam)
	  (
		( wid @initform defineParam("float" 1.0))
		( len @initform defineParam("float" 1.0))
	  )
) ; defClass

;;;;;;;;;;;;;;;;;;;;;;;;;;;;;;;;;;;;;;;;;;;;;;;;;;;;;;;;;;;;;;;;;;;;;;;;;;;;;;;;
; This method draws the shapes of the mesa resistor
;;;;;;;;;;;;;;;;;;;;;;;;;;;;;;;;;;;;;;;;;;;;;;;;;;;;;;;;;;;;;;;;;;;;;;;;;;;;;;;;
defmethod( draw ((device planarResistor))
  let( (wid len)
	   ;;;;;;;;;;;;;;;;;;;;;;;;;;;;;;;;;;;;;;
	   ;; Formal Parameters
	   wid = getParamValue(device 'wid)
    	   len = getParamValue(device 'len)
	   ;;;;;;;;;;;;;;;;;;;;;;;
	   ; set the cellview reference
	   cv = slotValue(device 'cvId)
	   ; Access the techfile
	   tf = makeInstance( 'techfile)
	   setName(tf cv~>libName)
	   getTechFileRef(tf)
	   ; FIME: Need to get mfg grid
           ;       from tf and check foral
           ;       parameters for proper
           ;       grid values - snap them
           ;       to closest grid if they are
           ;       not on grid. Warn user via
           ;       cadence ciw warning - to log??
	   ;;;;;;;;;;;;;;;;;;;;;;;;;;;;;;;;;;;;;;
	   ; Class Parameters From tech.db
	   ;;;;;;;;;;;;;;;;;;;;;;;;;;;;;;;;;;;;;;
	   ;FIXME: getEnclosureRule("sd" "mesa")
	   sdEnc = 1.0
	   minW = getWidthRule(tf "sd")+2*sdEnc
	   minL = 3*minW
	   sdConLen = getWidthRule(tf "sd")
	   ;;;;;;;;;;;;;;;;;;;;;;;;;;;;;;;;;;;;;;
	   ; Calculations
	   ;;;;;;;;;;;;;;;;;;;;;;;;;;;;;;;;;;;;;;
	   sdConWid = wid-2.0*sdEnc
	   ; Contact Transforms
	   cptrn = -1.0*len/2.0+sdConLen/2.0+sdEnc
	   cntrn = -1.0*cptrn
	   ;;;;;;;;;;;;;;;;;;;;;;;;;;;;;;;;;;;;;;
	   mesaFilm = makeInstance( 'rectangle )
	   setWid(mesaFilm wid)
	   setLen(mesaFilm len)
	   sdContact = makeInstance( 'rectangle )
	   setWid(sdContact sdConWid)
	   setLen(sdContact sdConLen)
	   ;;;;;;;;;;;;;;;;;;;;;;;;;;;;;;;;;;
	   ; Mesa Film Shape
	   mesaFilmShp = makeInstance( 'shape )
	   setVertices(mesaFilmShp genRect(mesaFilm))
	   setLayer(mesaFilmShp "mesa")
	   setPurpose(mesaFilmShp "drawing")
	   ;;;;;;;;;;;;;;;;;;;;;;;;;;;;;;;;;;
	   ; SD POS Contact Shape
	   sdConShpP = makeInstance( 'shape )
	   setVertices(sdConShpP genRect(sdContact))
	   setLayer(sdConShpP "sd")
	   setPurpose(sdConShpP "drawing")
	   ; Translate POS Contact to proper position
	   shapeTranslate(sdConShpP list(cptrn 0))
	   ;;;;;;;;;;;;;;;;;;;;;;;;;;;;;;;;;;
	   ; SD NEG Contact Shape
	   sdConShpN = makeInstance( 'shape )
	   setVertices(sdConShpN genRect(sdContact))
	   setLayer(sdConShpN "sd")
	   setPurpose(sdConShpN "drawing")
	   ; Translate NEG Contact to proper position
	   shapeTranslate(sdConShpN list(cntrn 0))
	   setCvRef(mesaFilmShp cv)
	   setCvRef(sdConShpP cv)
	   setCvRef(sdConShpN cv)
	   ;;;;;;;;;;;;;;;;;;;;;;;;;;;;;;
	   ; Render the resitor shapes
	   sub = render(mesaFilmShp)
	   cp = render(sdConShpP)
	   cn =render(sdConShpN)
	   ;;;;;;;;;;;;;;;;;;;;;;;;;;;;;;;
	   ; Add in electrical nets
	   pNet = dbMakeNet(cv "POS")
	   dbCreateTerm(pNet "P" "inputOutput")
	   nNet = dbMakeNet(cv "NEG")
	   dbCreateTerm(nNet "N" "inputOutput")
	   ;;;;;;;;;;;;;;;;;;;;;;;;;;;;;;;
	   ; Make a pin rectangle
	   pr = makeInstance( 'rectangle )
	   ;;;;;;;;;;;;;;;;;;;;;;;;;;;;;;;
	   ; Add in POS pin shape
	   ppShp = makeInstance( 'shape )
	   setVertices(ppShp genRect(pr))
	   setLayer(ppShp "sd")
	   setPurpose(ppShp "net")
	   ; Translate POS Pin Shape to proper position
	   shapeTranslate(ppShp list(cptrn  0))
	   ;;;;;;;;;;;;;;;;;;;;;;;;;;;;;;;
	   ; Add in POS pin shape
	   pnShp = makeInstance( 'shape )
	   setVertices(pnShp genRect(pr))
	   setLayer(pnShp "sd")
	   setPurpose(pnShp "net")
	   ; Translate POS Pin Shape to proper position
	   shapeTranslate(pnShp list(cntrn  0))
	   ;;;;;;;;;;;;;;;;;;;;;;;;;;;;;;;
	   ; Set the shape references to the
	   ; cv
	   setCvRef(ppShp  cv)
	   setCvRef(pnShp  cv)
	   ;;;;;;;;;;;;;;;;;;;;;;;;;;;;;;;;
	   ; Render the two pin shapes
	   pp = render(ppShp)
	   pn = render(pnShp)
	   ;;;;;;;;;;;;;;;;;;;;;;;;;;;;;;;
	   ; Add Electrical Pins to the Pin Shapes
	   dbCreatePin(pNet pp "pp")
	   dbCreatePin(nNet pp "pn")
  );let
);defmethod
