;;;;;;;;;;;;;;;;;;;;;;;;;;;;;;;;;;;;;;;;;;;;;;;;;;;;;;;;;;;;;;;;;;;;;;;;;;;;;;;;
;;;;;;;;;;;;;;;;  list.il: Some extensions to skill list functionality
;;;;;;;;;;;;;;;;;;;;;;;;;;;;;;;;;;;;;;;;;;;;;;;;;;;;;;;;;;;;;;;;;;;;;;;;;;;;;;;;
defclass( mesaResistor (PcellParam)
	  (
		( wid @initform defineParam("float" 1.0))
		( len @initform defineParam("float" 1.0))
	  )
) ; defClass

;;;;;;;;;;;;;;;;;;;;;;;;;;;;;;;;;;;;;;;;;;;;;;;;;;;;;;;;;;;;;;;;;;;;;;;;;;;;;;;;
; This method draws the shapes of the mesa resistor
;;;;;;;;;;;;;;;;;;;;;;;;;;;;;;;;;;;;;;;;;;;;;;;;;;;;;;;;;;;;;;;;;;;;;;;;;;;;;;;;
defmethod( draw ((device mesaResistor))
  let( (wid len sdEnc minW minL sdConLen sdConLen sdConWid cptrn cntrn
        mesaFilm  mesaFilmShp sdConShp sub cp cn pNet nNet pr ppShp pnShp
	pp pp)
	   ;;;;;;;;;;;;;;;;;;;;;;;;;;;;;;;;;;;;;;
	   ;; Formal Parameters
	   wid = getParamValue(device 'wid)
    	   len = getParamValue(device 'len)
	   ;;;;;;;;;;;;;;;;;;;;;;;
	   ; set the cellview reference
	   cv = slotValue(device 'cvId)
	   ; Access the techfile
	   ; FIXME: TF not set up for this yet
	   ;tf = makeInstance( 'techfile)
	   ;setName(tf cv~>libName)
	   ;getTechFileRef(tf)
	   ; FIME: Need to get mfg grid
           ;       from tf and check foral
           ;       parameters for proper
           ;       grid values - snap them
           ;       to closest grid if they are
           ;       not on grid. Warn user via
           ;       cadence ciw warning - to log??
	   ;;;;;;;;;;;;;;;;;;;;;;;;;;;;;;;;;;;;;;
	   ; Class Parameters From tech.db
	   ;;;;;;;;;;;;;;;;;;;;;;;;;;;;;;;;;;;;;;
	   ;FIXME: getEnclosureRule("sd" "mesa")
	   sdEnc = 1.0
	   ; FIXME: TF not set up
	   ;minW = getWidthRule(tf "sd")+2*sdEnc
	   minW = 0.5
	   minL = 3*minW
	   ; FIXME: TF not set up
	   ;sdConLen = getWidthRule(tf "sd")
	   sdConLen = 1.0
	   ;;;;;;;;;;;;;;;;;;;;;;;;;;;;;;;;;;;;;;
	   ; Calculations
	   ;;;;;;;;;;;;;;;;;;;;;;;;;;;;;;;;;;;;;;
	   sdConWid = wid-2.0*sdEnc
	   ; Contact Transforms
	   cptrn = -1.0*len/2.0+sdConLen/2.0+sdEnc
	   cntrn = -1.0*cptrn
	   ;;;;;;;;;;;;;;;;;;;;;;;;;;;;;;;;;;;;;;
	   ; Resistor Body
	   mesaFilm = makeInstance( 'rectangle )
	   setWidth(mesaFilm wid)
	   setHeight(mesaFilm len)
	   generate(mesaFilm)
	   ;;;;;;;;;;;;;;;;;;;;;;;;;;;;;;;;;;;;;;
	   ; Resistor Contacts
	   sdContact = makeInstance( 'rectangle )
	   setWidth(sdContact sdConWid)
	   setHeight(sdContact sdConLen)
	   generate(mesaFilm)
	   ;;;;;;;;;;;;;;;;;;;;;;;;;;;;;;;;;;
	   ; Mesa Film Polygon
	   mesaFilmShp = makeInstance( 'polygon2 )
	   setVertices(mesaFilmShp getVertices(mesaFilm))
	   setLayer(mesaFilmShp "resistor")
	   setPurpose(mesaFilmShp "drawing")
	   ;;;;;;;;;;;;;;;;;;;;;;;;;;;;;;;;;;
	   ; SD POS Contact Shape
	   sdConShp = makeInstance( 'shape )
	   setVertices(sdConShpP getVertices(sdContact))
	   setLayer(sdConShpP "electrode")
	   setPurpose(sdConShpP "drawing")
	   ; Translate POS Contact to proper position
	   shapeTranslate(sdConShpP list(cptrn 0))
	   ;;;;;;;;;;;;;;;;;;;;;;;;;;;;;;;;;;
	   ; SD NEG Contact Shape
	   sdConShpN = makeInstance( 'shape )
	   setVertices(sdConShpN getVertices(sdContact))
	   setLayer(sdConShpN "electrode")
	   setPurpose(sdConShpN "drawing")
	   ; Translate NEG Contact to proper position
	   shapeTranslate(sdConShpN list(cntrn 0))
	   setCvRef(mesaFilmShp cv)
	   setCvRef(sdConShpP cv)
	   setCvRef(sdConShpN cv)
	   ;;;;;;;;;;;;;;;;;;;;;;;;;;;;;;
	   ; Render the resitor shapes
	   sub = render(mesaFilmShp)
	   cp = render(sdConShpP)
	   cn =render(sdConShpN)
	   ;;;;;;;;;;;;;;;;;;;;;;;;;;;;;;;
	   ; Add in electrical nets
	   pNet = dbMakeNet(cv "POS")
	   dbCreateTerm(pNet "P" "inputOutput")
	   nNet = dbMakeNet(cv "NEG")
	   dbCreateTerm(nNet "N" "inputOutput")
	   ;;;;;;;;;;;;;;;;;;;;;;;;;;;;;;;
	   ; Make a pin rectangle
	   pr = makeInstance( 'rectangle )
	   ;;;;;;;;;;;;;;;;;;;;;;;;;;;;;;;
	   ; Add in POS pin shape
	   ppShp = makeInstance( 'shape )
	   setVertices(ppShp genRect(pr))
	   setLayer(ppShp "sd")
	   setPurpose(ppShp "net")
	   ; Translate POS Pin Shape to proper position
	   shapeTranslate(ppShp list(cptrn  0))
	   ;;;;;;;;;;;;;;;;;;;;;;;;;;;;;;;
	   ; Add in POS pin shape
	   pnShp = makeInstance( 'shape )
	   setVertices(pnShp genRect(pr))
	   setLayer(pnShp "sd")
	   setPurpose(pnShp "net")
	   ; Translate POS Pin Shape to proper position
	   shapeTranslate(pnShp list(cntrn  0))
	   ;;;;;;;;;;;;;;;;;;;;;;;;;;;;;;;
	   ; Set the shape references to the
	   ; cv
	   setCvRef(ppShp  cv)
	   setCvRef(pnShp  cv)
	   ;;;;;;;;;;;;;;;;;;;;;;;;;;;;;;;;
	   ; Render the two pin shapes
	   pp = render(ppShp)
	   pn = render(pnShp)
	   ;;;;;;;;;;;;;;;;;;;;;;;;;;;;;;;
	   ; Add Electrical Pins to the Pin Shapes
	   dbCreatePin(pNet pp "pp")
	   dbCreatePin(nNet pp "pn")
  );let
);defmethod
